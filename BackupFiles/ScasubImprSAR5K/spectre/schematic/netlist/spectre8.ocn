simulator( 'spectre )
design(	 "/home/janamani/.Simulations/ScasubImprSAR/spectre/schematic/netlist/netlist")
resultsDir( "/home/janamani/.Simulations/ScasubImprSAR/spectre/schematic" )
modelFile(
    '("/Cad/DesignK/UMC180NM/UMC_18_CMOS/../Models/Spectre/core_rf_v2d4.lib.scs" "tt")
    '("/Cad/DesignK/UMC180NM/UMC_18_CMOS/../Models/Spectre/io_rf_v2d3.lib.scs" "tt")
    '("/Cad/DesignK/UMC180NM/UMC_18_CMOS/../Models/Spectre/l_slcr20k_rf_v2d3.lib.scs" "typ")
    '("/Cad/DesignK/UMC180NM/UMC_18_CMOS/../Models/Spectre/mimcapm_rf_v2d3.lib.scs" "typ")
    '("/Cad/DesignK/UMC180NM/UMC_18_CMOS/../Models/Spectre/MM180_MIMCAP_V101.lib.scs" "mimcaps_typ")
    '("/Cad/DesignK/UMC180NM/UMC_18_CMOS/../Models/Spectre/MM180_REG18BPW_V123.lib.scs" "tt")
    '("/Cad/DesignK/UMC180NM/UMC_18_CMOS/../Models/Spectre/MM180_REG18_V124.lib.scs" "tt")
    '("/Cad/DesignK/UMC180NM/UMC_18_CMOS/../Models/Spectre/MM180_REG33BPW_V123.lib.scs" "tt")
    '("/Cad/DesignK/UMC180NM/UMC_18_CMOS/../Models/Spectre/MM180_REG33_V114.lib.scs" "tt")
    '("/Cad/DesignK/UMC180NM/UMC_18_CMOS/../Models/Spectre/MM180_RES_V133.lib.scs" "res_typ")
    '("/Cad/DesignK/UMC180NM/UMC_18_CMOS/../Models/Spectre/MM180_ZVT18_V121.lib.scs" "tt")
    '("/Cad/DesignK/UMC180NM/UMC_18_CMOS/../Models/Spectre/MM180_ZVT33_V113.lib.scs" "tt")
    '("/Cad/DesignK/UMC180NM/UMC_18_CMOS/../Models/Spectre/MM180_LVT33_V113.lib.scs" "tt")
    '("/Cad/DesignK/UMC180NM/UMC_18_CMOS/../Models/Spectre/MM180_LVT18_V113.lib.scs" "tt")
    '("/Cad/DesignK/UMC180NM/UMC_18_CMOS/../Models/Spectre/pad_rf_v2d3.lib.scs" "typ")
    '("/Cad/DesignK/UMC180NM/UMC_18_CMOS/../Models/Spectre/rnhr_rf_v2d3.lib.scs" "typ")
    '("/Cad/DesignK/UMC180NM/UMC_18_CMOS/../Models/Spectre/rnnpo_rf_v2d3.lib.scs" "typ")
    '("/Cad/DesignK/UMC180NM/UMC_18_CMOS/../Models/Spectre/rnppo_rf_v2d3.lib.scs" "typ")
    '("/Cad/DesignK/UMC180NM/UMC_18_CMOS/../Models/Spectre/vardiop_rf_v2d3.lib.scs" "typ")
    '("/Cad/DesignK/UMC180NM/UMC_18_CMOS/../Models/Spectre/varmis_18_rf_v2d3.lib.scs" "typ")
    '("/Cad/DesignK/UMC180NM/UMC_18_CMOS/../Models/Spectre/MM180_BJT_V112.mdl.scs" "")
    '("/Cad/DesignK/UMC180NM/UMC_18_CMOS/../Models/Spectre/MM180_DIODE_V113.mdl.scs" "")
)
analysis('tran ?stop "2m"  ?errpreset "conservative"  )
envOption(
	'analysisOrder  list("tran")
)
saveOption( 'currents "selected" )
saveOption( 'save "selected" )
save( 'v "/Vc" "/SIP" "/VIP" )
save( 'i "/V38/PLUS" "/V37/PLUS" "/V16/PLUS" "/V40/PLUS" )
temp( 27 )
run()
selectResult( 'tran )
plot(getData("/Vc") getData("/SIP") getData("/VIP") getData("/V38/PLUS") getData("/V37/PLUS") getData("/V16/PLUS") getData("/V40/PLUS") )
modelFile(
    '("/Cad/DesignK/UMC180NM/UMC_18_CMOS/../Models/Spectre/core_rf_v2d4.lib.scs" "tt")
    '("/Cad/DesignK/UMC180NM/UMC_18_CMOS/../Models/Spectre/io_rf_v2d3.lib.scs" "tt")
    '("/Cad/DesignK/UMC180NM/UMC_18_CMOS/../Models/Spectre/l_slcr20k_rf_v2d3.lib.scs" "typ")
    '("/Cad/DesignK/UMC180NM/UMC_18_CMOS/../Models/Spectre/mimcapm_rf_v2d3.lib.scs" "typ")
    '("/Cad/DesignK/UMC180NM/UMC_18_CMOS/../Models/Spectre/MM180_MIMCAP_V101.lib.scs" "mimcaps_typ")
    '("/Cad/DesignK/UMC180NM/UMC_18_CMOS/../Models/Spectre/MM180_REG18BPW_V123.lib.scs" "tt")
    '("/Cad/DesignK/UMC180NM/UMC_18_CMOS/../Models/Spectre/MM180_REG18_V124.lib.scs" "tt")
    '("/Cad/DesignK/UMC180NM/UMC_18_CMOS/../Models/Spectre/MM180_REG33BPW_V123.lib.scs" "tt")
    '("/Cad/DesignK/UMC180NM/UMC_18_CMOS/../Models/Spectre/MM180_REG33_V114.lib.scs" "tt")
    '("/Cad/DesignK/UMC180NM/UMC_18_CMOS/../Models/Spectre/MM180_RES_V133.lib.scs" "res_typ")
    '("/Cad/DesignK/UMC180NM/UMC_18_CMOS/../Models/Spectre/MM180_ZVT18_V121.lib.scs" "tt")
    '("/Cad/DesignK/UMC180NM/UMC_18_CMOS/../Models/Spectre/MM180_ZVT33_V113.lib.scs" "tt")
    '("/Cad/DesignK/UMC180NM/UMC_18_CMOS/../Models/Spectre/MM180_LVT33_V113.lib.scs" "tt")
    '("/Cad/DesignK/UMC180NM/UMC_18_CMOS/../Models/Spectre/MM180_LVT18_V113.lib.scs" "tt")
    '("/Cad/DesignK/UMC180NM/UMC_18_CMOS/../Models/Spectre/pad_rf_v2d3.lib.scs" "typ")
    '("/Cad/DesignK/UMC180NM/UMC_18_CMOS/../Models/Spectre/rnhr_rf_v2d3.lib.scs" "typ")
    '("/Cad/DesignK/UMC180NM/UMC_18_CMOS/../Models/Spectre/rnnpo_rf_v2d3.lib.scs" "typ")
    '("/Cad/DesignK/UMC180NM/UMC_18_CMOS/../Models/Spectre/rnppo_rf_v2d3.lib.scs" "typ")
    '("/Cad/DesignK/UMC180NM/UMC_18_CMOS/../Models/Spectre/vardiop_rf_v2d3.lib.scs" "typ")
    '("/Cad/DesignK/UMC180NM/UMC_18_CMOS/../Models/Spectre/varmis_18_rf_v2d3.lib.scs" "typ")
    '("/Cad/DesignK/UMC180NM/UMC_18_CMOS/../Models/Spectre/MM180_BJT_V112.mdl.scs" "")
    '("/Cad/DesignK/UMC180NM/UMC_18_CMOS/../Models/Spectre/MM180_DIODE_V113.mdl.scs" "")
)
run()
selectResult( 'tran )
plot(getData("/Vc") getData("/SIP") getData("/VIP") getData("/V38/PLUS") getData("/V37/PLUS") getData("/V16/PLUS") getData("/V40/PLUS") )
modelFile(
    '("/Cad/DesignK/UMC180NM/UMC_18_CMOS/../Models/Spectre/core_rf_v2d4.lib.scs" "tt")
    '("/Cad/DesignK/UMC180NM/UMC_18_CMOS/../Models/Spectre/io_rf_v2d3.lib.scs" "tt")
    '("/Cad/DesignK/UMC180NM/UMC_18_CMOS/../Models/Spectre/l_slcr20k_rf_v2d3.lib.scs" "typ")
    '("/Cad/DesignK/UMC180NM/UMC_18_CMOS/../Models/Spectre/mimcapm_rf_v2d3.lib.scs" "typ")
    '("/Cad/DesignK/UMC180NM/UMC_18_CMOS/../Models/Spectre/MM180_MIMCAP_V101.lib.scs" "mimcaps_typ")
    '("/Cad/DesignK/UMC180NM/UMC_18_CMOS/../Models/Spectre/MM180_REG18BPW_V123.lib.scs" "tt")
    '("/Cad/DesignK/UMC180NM/UMC_18_CMOS/../Models/Spectre/MM180_REG18_V124.lib.scs" "tt")
    '("/Cad/DesignK/UMC180NM/UMC_18_CMOS/../Models/Spectre/MM180_REG33BPW_V123.lib.scs" "tt")
    '("/Cad/DesignK/UMC180NM/UMC_18_CMOS/../Models/Spectre/MM180_REG33_V114.lib.scs" "tt")
    '("/Cad/DesignK/UMC180NM/UMC_18_CMOS/../Models/Spectre/MM180_RES_V133.lib.scs" "res_typ")
    '("/Cad/DesignK/UMC180NM/UMC_18_CMOS/../Models/Spectre/MM180_ZVT18_V121.lib.scs" "tt")
    '("/Cad/DesignK/UMC180NM/UMC_18_CMOS/../Models/Spectre/MM180_ZVT33_V113.lib.scs" "tt")
    '("/Cad/DesignK/UMC180NM/UMC_18_CMOS/../Models/Spectre/MM180_LVT33_V113.lib.scs" "tt")
    '("/Cad/DesignK/UMC180NM/UMC_18_CMOS/../Models/Spectre/MM180_LVT18_V113.lib.scs" "tt")
    '("/Cad/DesignK/UMC180NM/UMC_18_CMOS/../Models/Spectre/pad_rf_v2d3.lib.scs" "typ")
    '("/Cad/DesignK/UMC180NM/UMC_18_CMOS/../Models/Spectre/rnhr_rf_v2d3.lib.scs" "typ")
    '("/Cad/DesignK/UMC180NM/UMC_18_CMOS/../Models/Spectre/rnnpo_rf_v2d3.lib.scs" "typ")
    '("/Cad/DesignK/UMC180NM/UMC_18_CMOS/../Models/Spectre/rnppo_rf_v2d3.lib.scs" "typ")
    '("/Cad/DesignK/UMC180NM/UMC_18_CMOS/../Models/Spectre/vardiop_rf_v2d3.lib.scs" "typ")
    '("/Cad/DesignK/UMC180NM/UMC_18_CMOS/../Models/Spectre/varmis_18_rf_v2d3.lib.scs" "typ")
    '("/Cad/DesignK/UMC180NM/UMC_18_CMOS/../Models/Spectre/MM180_BJT_V112.mdl.scs" "")
    '("/Cad/DesignK/UMC180NM/UMC_18_CMOS/../Models/Spectre/MM180_DIODE_V113.mdl.scs" "")
)
analysis('tran ?stop "1m"  )
run()
selectResult( 'tran )
plot(getData("/Vc") getData("/SIP") getData("/VIP") getData("/V38/PLUS") getData("/V37/PLUS") getData("/V16/PLUS") getData("/V40/PLUS") )
modelFile(
    '("/Cad/DesignK/UMC180NM/UMC_18_CMOS/../Models/Spectre/core_rf_v2d4.lib.scs" "tt")
    '("/Cad/DesignK/UMC180NM/UMC_18_CMOS/../Models/Spectre/io_rf_v2d3.lib.scs" "tt")
    '("/Cad/DesignK/UMC180NM/UMC_18_CMOS/../Models/Spectre/l_slcr20k_rf_v2d3.lib.scs" "typ")
    '("/Cad/DesignK/UMC180NM/UMC_18_CMOS/../Models/Spectre/mimcapm_rf_v2d3.lib.scs" "typ")
    '("/Cad/DesignK/UMC180NM/UMC_18_CMOS/../Models/Spectre/MM180_MIMCAP_V101.lib.scs" "mimcaps_typ")
    '("/Cad/DesignK/UMC180NM/UMC_18_CMOS/../Models/Spectre/MM180_REG18BPW_V123.lib.scs" "tt")
    '("/Cad/DesignK/UMC180NM/UMC_18_CMOS/../Models/Spectre/MM180_REG18_V124.lib.scs" "tt")
    '("/Cad/DesignK/UMC180NM/UMC_18_CMOS/../Models/Spectre/MM180_REG33BPW_V123.lib.scs" "tt")
    '("/Cad/DesignK/UMC180NM/UMC_18_CMOS/../Models/Spectre/MM180_REG33_V114.lib.scs" "tt")
    '("/Cad/DesignK/UMC180NM/UMC_18_CMOS/../Models/Spectre/MM180_RES_V133.lib.scs" "res_typ")
    '("/Cad/DesignK/UMC180NM/UMC_18_CMOS/../Models/Spectre/MM180_ZVT18_V121.lib.scs" "tt")
    '("/Cad/DesignK/UMC180NM/UMC_18_CMOS/../Models/Spectre/MM180_ZVT33_V113.lib.scs" "tt")
    '("/Cad/DesignK/UMC180NM/UMC_18_CMOS/../Models/Spectre/MM180_LVT33_V113.lib.scs" "tt")
    '("/Cad/DesignK/UMC180NM/UMC_18_CMOS/../Models/Spectre/MM180_LVT18_V113.lib.scs" "tt")
    '("/Cad/DesignK/UMC180NM/UMC_18_CMOS/../Models/Spectre/pad_rf_v2d3.lib.scs" "typ")
    '("/Cad/DesignK/UMC180NM/UMC_18_CMOS/../Models/Spectre/rnhr_rf_v2d3.lib.scs" "typ")
    '("/Cad/DesignK/UMC180NM/UMC_18_CMOS/../Models/Spectre/rnnpo_rf_v2d3.lib.scs" "typ")
    '("/Cad/DesignK/UMC180NM/UMC_18_CMOS/../Models/Spectre/rnppo_rf_v2d3.lib.scs" "typ")
    '("/Cad/DesignK/UMC180NM/UMC_18_CMOS/../Models/Spectre/vardiop_rf_v2d3.lib.scs" "typ")
    '("/Cad/DesignK/UMC180NM/UMC_18_CMOS/../Models/Spectre/varmis_18_rf_v2d3.lib.scs" "typ")
    '("/Cad/DesignK/UMC180NM/UMC_18_CMOS/../Models/Spectre/MM180_BJT_V112.mdl.scs" "")
    '("/Cad/DesignK/UMC180NM/UMC_18_CMOS/../Models/Spectre/MM180_DIODE_V113.mdl.scs" "")
)
analysis('tran ?stop "400u"  )
run()
selectResult( 'tran )
plot(getData("/Vc") getData("/SIP") getData("/VIP") getData("/V38/PLUS") getData("/V37/PLUS") getData("/V16/PLUS") getData("/V40/PLUS") )
