// $ Spice netlist generated by v2lvs
simulator lang=spectre insensitive=yes
//  v2011.1_15.11    thu feb 10 17:20:50 pst 2011
//  global 0 gnd vcc
//  aliasGnd ( gnd 0 ) vsource type=dc dc=0
include "/Cad/DesignK/FaradayUMC180/DigitalCore/BackEnd/lvs/fsa0a_c_generic_core.scs"

subckt sarimprverilog ( clock reset compare ready clocktck clockcmp resetp resetn
+ saroutg sarout\[7\] sarout\[6\] sarout\[5\] sarout\[4\] sarout\[3\] sarout\[2\]
+ sarout\[1\] sarout\[0\] dataout\[7\] dataout\[6\] dataout\[5\] dataout\[4\] dataout\[3\]
+ dataout\[2\] dataout\[1\] dataout\[0\] )
xg298 ( saroutg resetn ) buf4
xg299 ( resetp reset ) buf4
xg1752 ( n158 n161 ) inv1s
xg1748 ( n161 statep\[0\] statep\[1\] ) or2
xg3366 ( sarout\[1\] n142 resetn ) nd2
xg3367 ( n142 sar\[1\] tempsar\[1\] ) or2
xsar_reg\[1\] ( sar\[1\] n121 clock resetn ) qdffrbs
xg3369 ( n121 n111 n112 n89 n166 ) oai112s
xg3370 ( sarout\[2\] n141 resetn ) nd2
xg3371 ( n141 sar\[2\] tempsar\[2\] ) or2
xg3374 ( n120 n110 n109 n119 ) nd3
xg3375 ( sarout\[3\] n140 resetn ) nd2
xg3376 ( n119 n88 sar\[3\] ) nd2s
xg3377 ( n140 sar\[3\] tempsar\[3\] ) or2
xsar_reg\[3\] ( sar\[3\] n118 clock resetn ) qdffrbs
xg3379 ( n118 n107 n95 n89 n167 n91 n103 ) oai222s
xg3380 ( sarout\[4\] n139 resetn ) nd2
xg3381 ( n139 sar\[4\] tempsar\[4\] ) or2
xg3384 ( n117 n108 n116 n95 n101 ) oai112s
xg3385 ( sarout\[5\] n137 resetn ) nd2
xg3386 ( n137 sar\[5\] tempsar\[5\] ) or2
xg3387 ( n116 n88 sar\[5\] ) nd2s
xsar_reg\[5\] ( sar\[5\] n115 clock resetn ) qdffrbn
xg3389 ( n115 n94 n95 n89 n168 n99 n91 ) oai222s
xg3390 ( sarout\[6\] n136 resetn ) nd2p
xg3391 ( n136 sar\[6\] tempsar\[6\] ) or2
xg3394 ( n114 n97 n104 n113 ) nd3
xg3395 ( sarout\[7\] n135 resetn ) nd2t
xg3396 ( n135 sar\[7\] tempsar\[7\] ) or2
xg3397 ( n113 n88 sar\[7\] ) nd2s
xg3398 ( n112 n96 n126 n90 ) nd3
xg3399 ( n111 n163 n92 dataout\[1\] ) or3b2
xg3400 ( n110 n96 n126 n83 ) nd3
xsar_reg\[7\] ( sar\[7\] n106 clock resetn ) qdffrbn
xg3402 ( n163 n105 n83 ) nd2s
xg3403 ( n109 n105 n92 dataout\[2\] ) nd3
xg3404 ( n108 n92 n100 dataout\[4\] ) nd3
xg3405 ( n125 n126 n87 n83 ) an3b2s
xready_reg ( ready n102 clock resetn ) qdffrbs
xg3407 ( n107 dataout\[3\] n127 ) or2b1s
xg3408 ( n126 n127 dataout\[3\] ) an2
xg3409 ( n106 n91 n98 ) nr2
xg3410 ( n105 n100 dataout\[3\] dataout\[4\] ) an3b2s
xg3411 ( n104 n92 n93 dataout\[6\] ) nd3
xg3412 ( n103 n100 dataout\[3\] n86 ) nd3
xg3413 ( n102 n159 ) inv1s
xg3414 ( n159 count\[3\] n164 ) or2
xg3415 ( n101 n128 n86 ) nd2s
xg3416 ( n127 n128 dataout\[4\] ) an2
xg3417 ( n100 n93 dataout\[5\] dataout\[6\] ) an3b2s
xg3418 ( n99 n93 n82 dataout\[5\] ) nd3
xg3419 ( n98 compare n5 dataout\[7\] n84 n81 flagn ) oa222
xg3420 ( n97 n96 n82 flagn ) nd3
xg3421 ( n164 n169 n10 ) nd2
xg3422 ( n128 n129 dataout\[5\] ) an2
xg3423 ( n95 n96 ) inv1s
xg3424 ( n96 n87 n91 ) nr2
xg3425 ( sarout\[0\] n143 resetn ) nd2
xg3426 ( n94 dataout\[5\] n129 ) or2b1s
xg3427 ( n93 compare flagn dataout\[7\] ) nr3
xg3429 ( clockcmp n161 reset clock ) an3b2s
xg3430 ( n91 n92 ) inv1s
xg3431 ( n92 n11 statep\[1\] ) nr2
xg3432 ( n90 n83 dataout\[1\] ) nr2
xg3433 ( n88 n89 ) inv1s
xg3434 ( n89 statep\[1\] n11 ) nd2
xg3435 ( n169 count\[0\] count\[1\] ) nr2
xg3436 ( n87 dataout\[7\] compare ) nd2s
xg3437 ( n129 n84 n82 ) nr2
xg3438 ( n176 flagn compare ) nd2s
xg3439 ( n143 n165 n170 ) nd2
xg3440 ( n86 dataout\[4\] ) inv1s
xg3441 ( resetn reset ) inv1s
xg3445 ( n84 flagn ) inv1s
xg3447 ( n83 dataout\[2\] ) inv1s
xg3449 ( n82 dataout\[6\] ) inv1s
xg3450 ( n81 compare ) inv1s
xg2 ( clocktck n158 clock reset ) an3b1
xtempsar_reg\[7\] ( tempsar\[7\] n80 clock resetn ) qdffrbn
xtempsar_reg\[5\] ( tempsar\[5\] n79 clock resetn ) qdffrbn
xtempsar_reg\[6\] ( tempsar\[6\] n78 clock resetn ) qdffrbn
xg3553 ( n80 n77 n31 n29 n176 ) oai112s
xg3554 ( n79 n48 n128 n72 n13 n19 tempsar\[5\] n16 n137 ) ao2222
xg3555 ( n78 n16 n136 n71 n13 n19 tempsar\[6\] n48 n129 ) ao2222
xtempsar_reg\[4\] ( tempsar\[4\] n76 clock resetn ) qdffrbn
xg3557 ( n77 n74 n13 n19 tempsar\[7\] ) aoi22s
xtempsar_reg\[3\] ( tempsar\[3\] n75 clock resetn ) qdffrbn
xg3559 ( n76 n48 n127 n64 n13 n19 tempsar\[4\] n16 n139 ) ao2222
xtempsar_reg\[2\] ( tempsar\[2\] n73 clock resetn ) qdffrbn
xg3561 ( n75 n48 n126 n61 n13 n19 tempsar\[3\] n16 n140 ) ao2222
xg3562 ( n74 n69 tempsar\[7\] n69 tempsar\[7\] ) moai1s
xstatep_reg\[0\] ( statep\[0\] n11 n70 clock resetn ) dffsbn
xg3564 ( n73 n30 n65 n32 ) nd3
xg3565 ( n72 n66 n63 n0 tempsar\[5\] ) oai112s
xg3566 ( n71 n68 tempsar\[6\] n68 tempsar\[6\] ) moai1s
xtempsar_reg\[1\] ( tempsar\[1\] n67 clock resetn ) qdffrbn
xg3568 ( n70 reset n62 n37 n38 ) aoi13hs
xg3569 ( n69 tempsar\[6\] n63 n1 ) mux2
xg3570 ( n68 n1 n63 ) an2
xg3571 ( n67 n43 n59 n34 ) nd3
xg3572 ( n66 n0 n58 tempsar\[5\] ) nd3
xg3573 ( n65 n54 n13 n19 tempsar\[2\] ) aoi22s
xg3574 ( n64 n60 tempsar\[4\] n60 tempsar\[4\] ) moai1s
xg3578 ( n63 tempsar\[5\] n58 ) or2
xg3579 ( n62 n11 n27 n53 ) oai12s
xg3580 ( n61 n56 n50 n45 tempsar\[3\] ) oai112s
xstatep_reg\[1\] ( statep\[1\] n6 n51 clock resetn ) dffsbn
xflagn_reg ( flagn dataout\[7\] flagn clock n28 ) qdfzn
xg3583 ( n60 n52 n50 ) an2
xg3585 ( n59 n49 n13 ) nd2s
xg3586 ( n58 tempsar\[4\] n50 ) or2
xg3587 ( n57 n24 n36 n11 statep\[1\] ) oai13s
xg3588 ( n56 n45 n40 tempsar\[3\] ) nd3
xg3589 ( n55 n35 n33 n43 n8 ) oai112s
xg3590 ( n54 n46 tempsar\[2\] n46 tempsar\[2\] ) moai1s
xcount_reg\[1\] ( count\[1\] n47 clock resetn ) qdffrbn
xcount_reg\[0\] ( count\[0\] n42 clock resetn ) qdffrbn
xg3595 ( n53 n23 n14 n168 n165 ) an4b1s
xg3596 ( n52 n2 tempsar\[3\] ) nd2s
xg3597 ( n51 n44 resetn ) an2
xg3598 ( n50 tempsar\[3\] n40 ) or2
xg3599 ( n49 n21 n5 n21 n5 ) moai1s
xdataout_reg\[0\] ( dataout\[0\] tempsar\[0\] dataout\[0\] clock n159 resetn ) qdfzrbn
xdataout_reg\[1\] ( dataout\[1\] tempsar\[1\] dataout\[1\] clock n159 resetn ) qdfzrbn
xdataout_reg\[2\] ( dataout\[2\] tempsar\[2\] dataout\[2\] clock n159 resetn ) qdfzrbn
xdataout_reg\[3\] ( dataout\[3\] tempsar\[3\] dataout\[3\] clock n159 resetn ) qdfzrbn
xdataout_reg\[4\] ( dataout\[4\] tempsar\[4\] dataout\[4\] clock n159 resetn ) qdfzrbn
xdataout_reg\[5\] ( dataout\[5\] tempsar\[5\] dataout\[5\] clock n159 resetn ) qdfzrbn
xdataout_reg\[6\] ( dataout\[6\] tempsar\[6\] dataout\[6\] clock n159 resetn ) qdfzrbn
xdataout_reg\[7\] ( dataout\[7\] tempsar\[7\] dataout\[7\] clock n159 resetn ) qdfzrbn
xg3608 ( n48 compare n29 ) an2b1s
xg3609 ( n47 n3 n22 ) an2
xg3610 ( n46 n26 n4 ) an2
xg3611 ( n45 n2 ) inv1s
xg3613 ( n44 n27 n17 n175 n11 ) oai112s
xg3614 ( n43 n30 dataout\[1\] ) or2b1s
xg3615 ( n42 n3 count\[0\] ) nd2
xg3616 ( n41 n3 n20 ) an2
xg3617 ( n40 tempsar\[2\] n4 ) or2
xg3619 ( n38 statep\[0\] statep\[1\] count\[2\] count\[0\] ) oai112s
xg3620 ( n37 n27 count\[3\] count\[1\] ) oai12s
xg3621 ( n36 n25 n163 n8 dataout\[1\] ) oa13s
xg3622 ( n35 n13 n170 n19 tempsar\[0\] ) aoi22s
xg3623 ( n34 n19 tempsar\[1\] n16 n142 ) aoi22s
xg3624 ( n33 n16 n143 ) nd2
xg3625 ( n32 n16 n141 ) nd2
xg3626 ( n31 n16 n135 ) nd2
xg3627 ( n30 n125 n12 ) nd2
xg3628 ( n29 n12 dataout\[7\] ) nd2
xg3630 ( n28 n13 resetn ) nd2
xg3631 ( n27 n161 n11 n6 ) oai12s
xg3632 ( n26 n5 tempsar\[1\] tempsar\[0\] ) nd3
xg3633 ( n25 n125 n8 dataout\[1\] ) nd3
xg3635 ( n24 n11 statep\[1\] sar\[1\] ) nd3
xg3636 ( n23 sar\[5\] sar\[1\] n15 ) nr3
xg3637 ( n22 count\[0\] count\[1\] count\[1\] count\[0\] ) moai1s
xg3638 ( n21 n170 tempsar\[1\] n170 tempsar\[1\] ) moai1s
xg3639 ( n20 n169 n10 n169 n10 ) moai1s
xg3640 ( n19 compare n6 ) nr2
xg3641 ( n18 n164 count\[3\] ) nd2s
xg3642 ( n17 n164 statep\[0\] ) nd2
xg3643 ( n16 statep\[1\] compare ) an2
xg3644 ( n15 n167 n166 ) nd2s
xg3645 ( n14 sar\[3\] sar\[7\] ) nr2
xg3646 ( n13 n6 n11 ) an2
xg3647 ( n12 statep\[1\] n11 ) nr2
xg3684 ( n8 dataout\[0\] ) inv1s
xg3719 ( n5 dataout\[7\] ) inv1s
xg3451 ( n4 tempsar\[1\] tempsar\[0\] dataout\[7\] ) or3b1
xg3726 ( n3 n159 n13 ) an2b1s
xg3727 ( n2 tempsar\[2\] n26 ) an2b1s
xg3728 ( n1 n0 tempsar\[5\] ) or2b1s
xg3729 ( n0 n52 tempsar\[4\] ) or2b1s
xg3730 ( n174 n3 n18 ) nd2
xsar_reg\[2\] ( sar\[2\] n166 n120 clock resetn ) dffrbn
xsar_reg\[4\] ( sar\[4\] n167 n117 clock resetn ) dffrbn
xsar_reg\[6\] ( sar\[6\] n168 n114 clock resetn ) dffrbn
xsar_reg\[0\] ( 1000 n165 n57 clock resetn ) dffrbn
xtempsar_reg\[0\] ( tempsar\[0\] n170 n55 clock resetn ) dffrbn
xcount_reg\[2\] ( count\[2\] n10 n41 clock resetn ) dffrbn
xcount_reg\[3\] ( count\[3\] n175 n174 clock resetn ) dffrbn
ends sarimprverilog
