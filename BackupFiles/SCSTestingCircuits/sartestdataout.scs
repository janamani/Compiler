// $ Spice netlist generated by v2lvs
simulator lang=spectre insensitive=yes
//  v2011.1_15.11    thu feb 10 17:20:50 pst 2011
//  global 0 gnd vcc
//  aliasGnd ( gnd 0 ) vsource type=dc dc=0
include "/Cad/DesignK/FaradayUMC180/DigitalCore/BackEnd/lvs/fsa0a_c_generic_core.scs"

subckt sartestdataout ( statep\[1\] statep\[0\] sarout\[7\] sarout\[6\] sarout\[5\]
+ sarout\[4\] sarout\[3\] sarout\[2\] sarout\[1\] sarout\[0\] clockt resetn
+ dataout\[7\] dataout\[6\] dataout\[5\] dataout\[4\] dataout\[3\] dataout\[2\]
+ dataout\[1\] dataout\[0\] )

xdataout_reg\[7\] ( dataout\[7\] sarout\[7\] dataout\[7\] clockt n101 n106 ) qdfzrbn
xdataout_reg\[6\] ( dataout\[6\] sarout\[6\] dataout\[6\] clockt n101 n106 ) qdfzrbn
xdataout_reg\[5\] ( dataout\[5\] sarout\[5\] dataout\[5\] clockt n101 n106 ) qdfzrbn
xdataout_reg\[4\] ( dataout\[4\] sarout\[4\]	dataout\[4\] clockt n101 n106 ) qdfzrbn
xdataout_reg\[3\] ( dataout\[3\] sarout\[3\]	dataout\[3\] clockt n101 n106 ) qdfzrbn
xdataout_reg\[2\] ( dataout\[2\] sarout\[2\]	dataout\[2\] clockt n101 n106 ) qdfzrbn
xdataout_reg\[1\] ( dataout\[1\] sarout\[1\]	dataout\[1\] clockt n101 n106 ) qdfzrbn
xdataout_reg\[0\] ( dataout\[0\] sarout\[0\]	dataout\[0\] clockt n101 n106 ) qdfzrbn
xg101 ( n101 n102 ) inv3ck
xg102 ( n102 n103 ) inv3
xg103 ( n103 n104 n105 ) nd2t
xg104 ( n104 statep\[1\] ) inv3
xg105 ( n105 statep\[0\] ) inv3
xg106 ( n106 reset ) inv2

ends sartestdataout
