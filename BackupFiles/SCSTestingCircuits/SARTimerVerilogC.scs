// $ Spice netlist generated by v2lvs
simulator lang=spectre insensitive=yes
//  v2011.1_15.11    thu feb 10 17:20:50 pst 2011
//  global 0 gnd vcc
//  aliasGnd ( gnd 0 ) vsource type=dc dc=0
include "/Cad/DesignK/FaradayUMC180/DigitalCore/BackEnd/lvs/fsa0a_c_generic_core.scs"

subckt sartimer4verilog ( statep\[1\] statep\[0\] sarout\[7\] sarout\[6\] sarout\[5\]
+ sarout\[4\] sarout\[3\] sarout\[2\] sarout\[1\] sarout\[0\] clockt reset inc dcr
+ ready resetp resetn saroutis saroutds saroutig saroutdg saroutcg clockdcr clockinc
+ clocktck dataout\[7\] dataout\[6\] dataout\[5\] dataout\[4\] dataout\[3\] dataout\[2\]
+ dataout\[1\] dataout\[0\] timerout\[3\] timerout\[2\] timerout\[1\] timerout\[0\]
+ sarouti\[7\] sarouti\[6\] sarouti\[5\] sarouti\[4\] sarouti\[3\] sarouti\[2\]
+ sarouti\[1\] sarouti\[0\] saroutd\[7\] saroutd\[6\] saroutd\[5\] saroutd\[4\]
+ saroutd\[3\] saroutd\[2\] saroutd\[1\] saroutd\[0\] saroutc\[7\] saroutc\[6\]
+ saroutc\[5\] saroutc\[4\] saroutc\[3\] saroutc\[2\] saroutc\[1\] saroutc\[0\]
+ )

xdataout_reg\[7\] ( dataout\[7\] sarout\[7\] dataout\[7\] clockt n101 n106 ) qdfzrbn
xdataout_reg\[6\] ( dataout\[6\] sarout\[6\] dataout\[6\] clockt n101 n106 ) qdfzrbn
xdataout_reg\[5\] ( dataout\[5\] sarout\[5\] dataout\[5\] clockt n101 n106 ) qdfzrbn
xdataout_reg\[4\] ( dataout\[4\] sarout\[4\]	dataout\[4\] clockt n101 n106 ) qdfzrbn
xdataout_reg\[3\] ( dataout\[3\] sarout\[3\]	dataout\[3\] clockt n101 n106 ) qdfzrbn
xdataout_reg\[2\] ( dataout\[2\] sarout\[2\]	dataout\[2\] clockt n101 n106 ) qdfzrbn
xdataout_reg\[1\] ( dataout\[1\] sarout\[1\]	dataout\[1\] clockt n101 n106 ) qdfzrbn
xdataout_reg\[0\] ( dataout\[0\] sarout\[0\]	dataout\[0\] clockt n101 n106 ) qdfzrbn
xg101 ( n101 n102 ) inv3ck
xg102 ( n102 n103 ) inv3
xg103 ( n104 statep\[1\] ) inv3
xg104 ( n105 statep\[0\] ) inv3
xg105 ( n103 n104 n105 ) nd2t
xg106 ( n106 reset ) inv2

xg201 ( saroutcg resetn ) buf2
xg202 ( saroutdg resetn ) buf2
xg203 ( saroutig resetn ) buf2
xg204 ( saroutds saroutis ) buf2
xg205 ( saroutis resetp ) buf2
xg206 ( resetp reset ) buf2
xg207 ( resetn resetp ) inv2

xg300 ( clocktck clockdcr ) buf2
xg301 ( clockinc clockdcr ) buf2
xg303 ( clockdcr clockt resetp n301 ) nr3t
xg304 ( n301 n302 n304 ) nr2
xg305 ( n302 n303 ) inv1s
xg306 ( n303 statep\[1\] statep\[0\] ) nd2p
xg307 ( n304 n305 n308 n309 ) aoi12s
xg308 ( n305 n306 n307 ) nd2t
xg309 ( n306 statep\[1\] ) inv3
xg310 ( n307 statep\[0\] ) inv3
xg311 ( n308 dcr inc ) or2
xg302 ( n309 reset ) inv1s

xsaroutc_reg\[7\] ( n401         4001 n402 clockt n410 ) dffsbn
xsaroutc_reg\[6\] ( n411		   4002 n403 clockt n410 ) dffsbn
xsaroutc_reg\[5\] ( saroutc\[5\] 4003 n404 clockt n410 ) dffsbn
xsaroutc_reg\[4\] ( saroutc\[4\] 4004 n405 clockt n410 ) dffsbn
xsaroutc_reg\[3\] ( saroutc\[3\] 4005 n406 clockt n410 ) dffsbn
xsaroutc_reg\[2\] ( saroutc\[2\] 4006 n407 clockt n410 ) dffsbn
xsaroutc_reg\[1\] ( saroutc\[1\] 4007 n408 clockt n410 ) dffsbn
xsaroutc_reg\[0\] ( saroutc\[0\] 4008 n409 clockt n410 ) dffsbn
xg401 ( saroutc\[7\] n401 ) buf8
xg402 ( saroutc\[6\] n411 ) buf3
xg403 ( n402 sarout\[7\] ) inv2
xg404 ( n403 sarout\[6\] ) inv2
xg405 ( n404 sarout\[5\] ) inv2
xg406 ( n405 sarout\[4\] ) inv2
xg407 ( n406 sarout\[3\] ) inv2
xg408 ( n407 sarout\[2\] ) inv2
xg409 ( n408 sarout\[1\] ) inv2
xg410 ( n409 sarout\[0\] ) inv2
xg411 ( n410 reset ) inv1s

xsarouti_reg\[7\] ( n501 			5001 n502 clockt n503 ) dffsbn
xsarouti_reg\[6\] ( sarouti\[6\] 5002 n504 clockt n503 ) dffsbn
xsarouti_reg\[5\] ( sarouti\[5\] 5003 n505 clockt n503 ) dffsbn
xsarouti_reg\[4\] ( sarouti\[4\] 5004 n506 clockt n503 ) dffsbn
xsarouti_reg\[3\] ( sarouti\[3\] 5005 n507 clockt n503 ) dffsbn
xsarouti_reg\[2\] ( sarouti\[2\] 5006 n508 clockt n503 ) dffsbn
xsarouti_reg\[1\] ( sarouti\[1\] 5007 n509 clockt n503 ) dffsbn
xsarouti_reg\[0\] ( sarouti\[0\] 5008 n510 clockt n503 ) dffsbn
xg501 ( sarouti\[7\] n501 ) buf8
xg502 ( n503 reset ) inv1s
xg503 ( n502 sarout\[7\] n511 sarouti\[7\] n512 ) moai1
xg504 ( n512 statep\[0\] statep\[1\] ) xor2h
xg505 ( n511 n512 n513 sarout\[6\] ) ao12
xg506 ( n513 n514 n515 ) nr2p
xg507 ( n514 sarout\[5\] ) inv2
xg508 ( n515 n516 sarout\[4\] sarout\[3\] ) nd3p
xg509 ( n516 n517 n518 ) nr2t
xg510 ( n518 sarout\[0\] sarout\[1\] ) nd2p
xg511 ( n517 sarout\[2\] ) inv1
xg512 ( n504 n519 n512 sarouti\[6\] n512 ) moai1
xg513 ( n519 n513 n520 sarout\[6\] n513 ) maoi1
xg514 ( n520 sarout\[6\] sarout\[7\] ) an2b1s
xg515 ( n505 n521 n512 sarouti\[5\] n512 ) moai1
xg516 ( n521 n522 n513 n523 ) aoi12s
xg517 ( n522 n515 sarout\[5\] ) an2b1s
xg518 ( n523 sarout\[7\] sarout\[6\] ) nd2p
xg519 ( n506 n512 n524 sarouti\[4\] ) mux2
xg520 ( n524 n525 n515 n526 sarout\[4\] ) oai22s
xg521 ( n525 n514 n523 ) nr2
xg522 ( n526 n527 ) inv1s
xg523 ( n527 n516 sarout\[3\] ) nd2
xg524 ( n507 n512 n528 sarouti\[3\] ) mux2
xg525 ( n528 n529 n527 n530 sarout\[3\] ) oai22s
xg526 ( n529 sarout\[5\] sarout\[4\] sarout\[7\] sarout\[6\] ) an4
xg527 ( n530 n516 ) buf1
xg528 ( n508 n512 n531 sarouti\[2\] ) mux2
xg529 ( n531 n532 n533 n534 sarout\[2\] ) oai22s
xg530 ( n532 n530 ) inv1s
xg531 ( n533 n529 sarout\[3\] ) an2s
xg532 ( n534 n518 ) inv1s
xg533 ( n509 n535 n512 sarouti\[1\] n512 ) moai1
xg534 ( n535 n536 n534 sarout\[0\] sarout\[1\] ) maoi1
xg535 ( n536 n537 ) inv1
xg536 ( n537 sarout\[4\] sarout\[3\] sarout\[2\] n525 ) an4
xg537 ( n510 n538 n539 ) nd2s
xg538 ( n538 n512 n540 sarout\[0\] ) or3b2
xg539 ( n540 n537 sarout\[1\] ) nd2s
xg540 ( n539 sarouti\[0\] n512 ) nd2s

xsaroutd_reg\[7\] ( n601 			6001 n602 clockt n603 ) dffsbn
xsaroutd_reg\[6\] ( n604 			6002 n605 clockt n603 ) dffsbn
xsaroutd_reg\[5\] ( saroutd\[5\] 6003 n606 clockt n603 ) dffsbp
xsaroutd_reg\[4\] ( saroutd\[4\] 6004 n607 clockt n603 ) dffsbn
xsaroutd_reg\[3\] ( saroutd\[3\] 6005 n608 clockt n603 ) dffsbn
xsaroutd_reg\[2\] ( saroutd\[2\] 6006 n609 clockt n603 ) dffsbn
xsaroutd_reg\[1\] ( saroutd\[1\] 6007 n610 clockt n603 ) dffsbn
xsaroutd_reg\[0\] ( saroutd\[0\] 6008 n611 clockt n603 ) dffsbn
xg601 ( saroutd\[7\] n601 ) buf6ck
xg602 ( saroutd\[6\] n604 ) buf3
xg603 ( n603 reset ) inv1s
xg604 ( n602 n612 n613 n614 ) ao12
xg605 ( n612 n615 sarout\[7\] n601 n616 ) moai1s
xg606 ( n615 n617 ) inv4
xg607 ( n617 n616 ) inv6
xg608 ( n616 statep\[0\] statep\[1\] ) xor2h
xg609 ( n613 n618 ) inv1s
xg610 ( n618 n619 n620 ) nd2p
xg611 ( n619 sarout\[4\] n621 ) nr2p
xg612 ( n621 n622 ) inv2
xg613 ( n622 n623 n624 ) nr2t
xg614 ( n623 sarout\[3\] ) buf1ck
xg615 ( n624 n625 n626 ) nd2p
xg616 ( n625 sarout\[1\] sarout\[0\] ) nr2p
xg617 ( n626 sarout\[2\] ) inv2
xg618 ( n620 sarout\[5\] ) inv1s
xg619 ( n614 sarout\[6\] n616 ) nr2p
xg620 ( n605 n627 n628 ) nd2p
xg621 ( n627 n629 n617 ) nd2p
xg622 ( n629 sarout\[6\] n618 ) xor2hs
xg623 ( n628 n630 n604 n615 ) aoi12s
xg624 ( n630 n631 ) inv1s
xg625 ( n631 n614 n632 ) nd2p
xg626 ( n632 n634 n635 n626 n633 ) an4b1
xg627 ( n634 sarout\[5\] sarout\[7\] ) nr2
xg628 ( n635 sarout\[1\] ) inv1
xg629 ( n633 sarout\[3\] sarout\[4\] ) or2
xg630 ( n606 n636 n631 n637 ) nd3
xg631 ( n636 n638 n617 ) nd2s
xg632 ( n638 sarout\[5\] n619 ) xnr2hs
xg633 ( n637 saroutd\[5\] n615 ) nd2
xg634 ( n607 n631 n639 n640 n615 ) oai112s
xg635 ( n639 saroutd\[4\] n615 ) nd2
xg636 ( n640 n622 sarout\[4\] ) xor2hs
xg637 ( n608 n641 n631 ) nd2
xg638 ( n641 n642 n617 n615 saroutd\[3\] ) aoi22s
xg639 ( n642 n624 n623 ) xor2hs
xg640 ( n609 n643 n631 ) nd2
xg641 ( n643 n617 n644 n615 saroutd\[2\] ) aoi22s
xg642 ( n644 n625 sarout\[2\] ) xnr2hs
xg643 ( n610 n645 n631 ) nd2
xg644 ( n645 n617 n646 n615 saroutd\[1\] ) aoi22s
xg645 ( n646 sarout\[0\] n635 sarout\[1\] ) mxl2s
xg646 ( n611 n631 n647 ) nd2
xg647 ( n647 n615 saroutd\[0\] n617 sarout\[0\] ) aoi22s

xtimerout_reg\[3\] ( timerout\[3\] n701 clockt n705 ) qdffrbs
xtimerout_reg\[2\] ( timerout\[2\] n702 clockt n705 ) qdffrbs
xtimerout_reg\[1\] ( timerout\[1\] n703 clockt n705 ) qdffrbs
xtimerout_reg\[0\] ( timerout\[0\] n704 clockt n705 ) qdffrbs
xg701 ( n705 reset ) inv1s
xg702 ( n701 n706 n707 n708 ) mxl2hs
xg703 ( n706 n709 n710 ) nd2f
xg704 ( n709 n711 temptmr\[3\] ) nd2p
xg705 ( n711 n712 n713 ) nr2p
xg706 ( n712 temptmr\[2\] ) inv1s
xg707 ( n713 temptmr\[1\] temptmr\[0\] ) nd2
xg708 ( n710 flagtmr n714 ) or2
xg709 ( n714 n715 n716 ) nd2p
xg710 ( n715 n717 n718 ) nd2s
xg711 ( n717 statep\[0\] statep\[1\] ) nr2
xg712 ( n718 inc dcr ) nr2
xg713 ( n716 reset statep\[0\] statep\[1\] ) aoi12s
xg714 ( n707 timerout\[3\] ) inv1s
xg715 ( n708 temptmr\[3\] ) inv1s
xg716 ( n702 n706 n719 n712 ) mxl2hs
xg717 ( n719 timerout\[2\] ) inv1s
xg718 ( n703 n706 n720 n721 ) mxl2hs
xg719 ( n720 timerout\[1\] ) inv1s
xg720 ( n721 temptmr\[1\] ) inv1s
xg721 ( n704 n706 n722 n723 ) mxl2hs
xg722 ( n723 temptmr\[0\] ) inv1s
xg723 ( n722 timerout\[0\] ) inv1s
xtemptmr_reg\[3\] ( temptmr\[3\] n724 clockt n705 ) qdffrbn
xtemptmr_reg\[2\] ( temptmr\[2\] n725 clockt n705 ) qdffrbn
xtemptmr_reg\[1\] ( temptmr\[1\] n726 clockt n705 ) qdffrbn
xtemptmr_reg\[0\] ( temptmr\[0\] n727 clockt n705 ) qdffrbn
xg724 ( n724 n706 n728 n708 ) aoi12s
xg725 ( n728 n711 ) inv1s
xg726 ( n725 n713 n712 temptmr\[2\] n706 ) muxb2
xg727 ( n726 temptmr\[0\] temptmr\[1\] n721 n706 ) muxb2
xg728 ( n727 n729 temptmr\[0\] ) nd2
xg729 ( n729 n706 ) inv2
xflagtmr_reg ( flagtmr n730 clockt n705 ) qdffrbn
xready_reg ( ready n706 clockt n705 ) qdffrbs
xg730 ( n730 n729 n714 ) nd2

ends sartimer4verilog
