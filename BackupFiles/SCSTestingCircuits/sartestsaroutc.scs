// $ Spice netlist generated by v2lvs
simulator lang=spectre insensitive=yes
//  v2011.1_15.11    thu feb 10 17:20:50 pst 2011
//  global 0 gnd vcc
//  aliasGnd ( gnd 0 ) vsource type=dc dc=0
include "/Cad/DesignK/FaradayUMC180/DigitalCore/BackEnd/lvs/fsa0a_c_generic_core.scs"

subckt sartestsaroutc  ( sarout\[7\] sarout\[6\] sarout\[5\]
+ sarout\[4\] sarout\[3\] sarout\[2\] sarout\[1\] sarout\[0\] clockt reset
+ saroutc\[7\] saroutc\[6\] saroutc\[5\] saroutc\[4\] saroutc\[3\] saroutc\[2\] saroutc\[1\] saroutc\[0\] )

xsaroutc_reg\[7\] ( n401         4001 n402 clockt n410 ) dffsbn
xsaroutc_reg\[6\] ( saroutc\[6\] 4002 n403 clockt n410 ) dffsbt
xsaroutc_reg\[5\] ( saroutc\[5\] 4003 n404 clockt n410 ) dffsbp
xsaroutc_reg\[4\] ( saroutc\[4\] 4004 n405 clockt n410 ) dffsbn
xsaroutc_reg\[3\] ( saroutc\[3\] 4005 n406 clockt n410 ) dffsbn
xsaroutc_reg\[2\] ( saroutc\[2\] 4006 n407 clockt n410 ) dffsbn
xsaroutc_reg\[1\] ( saroutc\[1\] 4007 n408 clockt n410 ) dffsbn
xsaroutc_reg\[0\] ( saroutc\[0\] 4008 n409 clockt n410 ) dffsbn
xg401 ( saroutc\[7\] n401 ) buf6ck
xg402 ( n402 sarout\[7\] ) inv2
xg403 ( n403 sarout\[6\] ) inv2
xg404 ( n404 sarout\[5\] ) inv2
xg405 ( n405 sarout\[4\] ) inv2
xg406 ( n406 sarout\[3\] ) inv2
xg407 ( n407 sarout\[2\] ) inv2
xg408 ( n408 sarout\[1\] ) inv2
xg409 ( n409 sarout\[0\] ) inv2
xg410 ( n410 reset ) inv1s

ends sartestsaroutc
