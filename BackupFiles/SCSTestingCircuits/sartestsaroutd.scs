// $ Spice netlist generated by v2lvs
simulator lang=spectre insensitive=yes
//  v2011.1_15.11    thu feb 10 17:20:50 pst 2011
//  global 0 gnd vcc
//  aliasGnd ( gnd 0 ) vsource type=dc dc=0
include "/Cad/DesignK/FaradayUMC180/DigitalCore/BackEnd/lvs/fsa0a_c_generic_core.scs"

subckt sartestsaroutd  ( statep\[1\] statep\[0\] sarout\[7\] sarout\[6\] sarout\[5\]
+ sarout\[4\] sarout\[3\] sarout\[2\] sarout\[1\] sarout\[0\] clockt reset
+ saroutd\[7\] saroutd\[6\] saroutd\[5\] saroutd\[4\]
+ saroutd\[3\] saroutd\[2\] saroutd\[1\] saroutd\[0\] )

xsaroutd_reg\[7\] ( n601 			6001 n602 clockt n603 ) dffsbn
xsaroutd_reg\[6\] ( saroutd\[6\]	6002 n605 clockt n603 ) dffsbt
xsaroutd_reg\[5\] ( saroutd\[5\] 6003 n606 clockt n603 ) dffsbp
xsaroutd_reg\[4\] ( saroutd\[4\] 6004 n607 clockt n603 ) dffsbn
xsaroutd_reg\[3\] ( saroutd\[3\] 6005 n608 clockt n603 ) dffsbn
xsaroutd_reg\[2\] ( saroutd\[2\] 6006 n609 clockt n603 ) dffsbn
xsaroutd_reg\[1\] ( saroutd\[1\] 6007 n610 clockt n603 ) dffsbn
xsaroutd_reg\[0\] ( saroutd\[0\] 6008 n611 clockt n603 ) dffsbn
xg601 ( saroutd\[7\] n601 ) buf6ck
xg602 ( n603 reset ) inv1s
xg603 ( n602 n612 n613 n614 ) ao12
xg604 ( n612 n615 sarout\[7\] n601 n616 ) moai1s
xg605 ( n615 n617 ) inv4
xg606 ( n617 n616 ) inv6
xg607 ( n616 statep\[0\] statep\[1\] ) xor2h
xg608 ( n613 n618 ) inv1s
xg609 ( n618 n619 n620 ) nd2p
xg610 ( n619 sarout\[4\] n621 ) nr2p
xg611 ( n621 n622 ) inv2
xg612 ( n622 n623 n624 ) nr2t
xg613 ( n623 sarout\[3\] ) buf1ck
xg614 ( n624 n625 n626 ) nd2p
xg615 ( n625 sarout\[1\] sarout\[0\] ) nr2p
xg616 ( n626 sarout\[2\] ) inv2
xg617 ( n620 sarout\[5\] ) inv1s
xg618 ( n614 sarout\[6\] n616 ) nr2p
xg619 ( n605 n627 n628 ) nd2p
xg620 ( n627 n629 n617 ) nd2p
xg621 ( n629 sarout\[6\] n618 ) xor2hs
xg622 ( n628 n630 n604 n615 ) aoi12s
xg623 ( n630 n631 ) inv1s
xg624 ( n631 n614 n632 ) nd2p
xg625 ( n632 n634 n635 n626 n633 ) an4b1
xg626 ( n634 sarout\[5\] sarout\[7\] ) nr2
xg627 ( n635 sarout\[1\] ) inv1
xg628 ( n633 sarout\[3\] sarout\[4\] ) or2
xg629 ( n606 n636 n631 n637 ) nd3
xg630 ( n636 n638 n617 ) nd2s
xg631 ( n638 sarout\[5\] n619 ) xnr2hs
xg632 ( n637 saroutd\[5\] n615 ) nd2
xg633 ( n607 n631 n639 n640 n615 ) oai112s
xg634 ( n639 saroutd\[4\] n615 ) nd2
xg635 ( n640 n622 sarout\[4\] ) xor2hs
xg636 ( n608 n641 n631 ) nd2
xg637 ( n641 n642 n617 n615 saroutd\[3\] ) aoi22s
xg638 ( n642 n624 n623 ) xor2hs
xg639 ( n609 n643 n631 ) nd2
xg640 ( n643 n617 n644 n615 saroutd\[2\] ) aoi22s
xg641 ( n644 n625 sarout\[2\] ) xnr2hs
xg642 ( n610 n645 n631 ) nd2
xg643 ( n645 n617 n646 n615 saroutd\[1\] ) aoi22s
xg644 ( n646 sarout\[0\] n635 sarout\[1\] ) mxl2s
xg645 ( n611 n631 n647 ) nd2
xg646 ( n647 n615 saroutd\[0\] n617 sarout\[0\] ) aoi22s
ends sartestsaroutd
