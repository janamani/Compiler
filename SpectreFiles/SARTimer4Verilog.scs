// $ Spice netlist generated by v2lvs
simulator lang=spectre insensitive=yes
//  v2011.1_15.11    thu feb 10 17:20:50 pst 2011
//  global 0 gnd vcc
//  aliasGnd ( gnd 0 ) vsource type=dc dc=0
include "/Cad/DesignK/FaradayUMC180/DigitalCore/BackEnd/lvs/fsa0a_c_generic_core.scs"

subckt sartimer4verilog ( statep\[1\] statep\[0\] sarout\[7\] sarout\[6\] sarout\[5\]
+ sarout\[4\] sarout\[3\] sarout\[2\] sarout\[1\] sarout\[0\] clockt reset inc dcr
+ ready resetp resetn saroutis saroutds saroutig saroutdg saroutcg clockdcr clockinc
+ clocktck dataout\[7\] dataout\[6\] dataout\[5\] dataout\[4\] dataout\[3\] dataout\[2\]
+ dataout\[1\] dataout\[0\] timerout\[3\] timerout\[2\] timerout\[1\] timerout\[0\]
+ sarouti\[7\] sarouti\[6\] sarouti\[5\] sarouti\[4\] sarouti\[3\] sarouti\[2\]
+ sarouti\[1\] sarouti\[0\] saroutd\[7\] saroutd\[6\] saroutd\[5\] saroutd\[4\]
+ saroutd\[3\] saroutd\[2\] saroutd\[1\] saroutd\[0\] saroutc\[7\] saroutc\[6\]
+ saroutc\[5\] saroutc\[4\] saroutc\[3\] saroutc\[2\] saroutc\[1\] saroutc\[0\]
+ )
xg200 ( clocktck clockdcr ) buf4
xg201 ( clockinc clockdcr ) buf4
xg202 ( saroutcg resetn ) buf4
xg203 ( saroutdg resetn ) buf4
xg204 ( saroutig resetn ) buf4
xg205 ( saroutds saroutis ) buf4
xg206 ( saroutis resetp ) buf4
xg408 ( sarouti\[7\] n158 ) buf6ck
xg407 ( saroutd\[7\] n166 ) buf6ck
xg406 ( resetp reset ) buf2
xg469 ( n111 n357 ) inv1s
xready_reg ( ready n250 clockt resetn ) qdffrbs
xg454 ( clockdcr clockt resetp n76 ) nr3t
xsaroutc_reg\[1\] ( saroutc\[1\] 1000 n214 clockt resetn ) dffsbn
xsaroutc_reg\[0\] ( saroutc\[0\] 1001 n8 clockt resetn ) dffsbn
xsaroutc_reg\[7\] ( n277 1002 n109 clockt resetn ) dffsbn
xsaroutc_reg\[6\] ( saroutc\[6\] 1003 n110 clockt resetn ) dffsbn
xsaroutc_reg\[5\] ( saroutc\[5\] 1004 n446 clockt resetn ) dffsbn
xsaroutc_reg\[4\] ( saroutc\[4\] 1005 n442 clockt resetn ) dffsbn
xsaroutc_reg\[3\] ( saroutc\[3\] 1006 n118 clockt resetn ) dffsbn
xsaroutc_reg\[2\] ( saroutc\[2\] 1007 n316 clockt resetn ) dffsbn
xg473 ( n78 temptmr\[3\] temptmr\[2\] ) nd2
xg474 ( n77 temptmr\[1\] temptmr\[0\] ) nd2
xg475 ( n76 n111 n494 ) nr2
xg478 ( n110 sarout\[6\] ) inv1s
xg479 ( n109 sarout\[7\] ) inv1s
xg480 ( resetn resetp ) inv2
xg483 ( n118 n369 ) inv1s
xsaroutd_reg\[7\] ( n166 1008 n75 clockt resetn ) dffsbn
xg1319 ( n75 n405 n19 n74 n189 ) oai112h
xsaroutd_reg\[6\] ( saroutd\[6\] 1009 n364 clockt resetn ) dffsbt
xg1321 ( n74 sarout\[7\] n399 ) xor2hs
xsaroutd_reg\[5\] ( 1010 n433 n406 clockt resetn ) dffsbn
xsaroutd_reg\[4\] ( saroutd\[4\] 1011 n68 clockt resetn ) dffsbn
xg1330 ( n68 n321 n405 ) nd2
xsaroutd_reg\[3\] ( saroutd\[3\] 1012 n64 clockt resetn ) dffsbn
xg1336 ( n64 n62 n405 ) nd2
xg1338 ( n62 n315 n56 n189 saroutd\[3\] ) aoi22s
xsaroutd_reg\[2\] ( saroutd\[2\] 1013 n417 clockt resetn ) dffsbn
xtemptmr_reg\[3\] ( temptmr\[3\] n60 clockt resetn ) qdffrbn
xg1342 ( n60 n57 n250 ) nr2
xtemptmr_reg\[2\] ( temptmr\[2\] n54 clockt resetn ) qdffrbn
xg1346 ( n57 temptmr\[3\] n2 ) xnr2hs
xg1347 ( n56 n453 n369 n453 n369 ) moai1
xsarouti_reg\[1\] ( sarouti\[1\] 1014 n50 clockt resetn ) dffsbn
xsarouti_reg\[2\] ( sarouti\[2\] 1015 n317 clockt resetn ) dffsbn
xsarouti_reg\[3\] ( sarouti\[3\] 1016 n48 clockt resetn ) dffsbn
xsarouti_reg\[5\] ( sarouti\[5\] 1017 n46 clockt resetn ) dffsbp
xsarouti_reg\[6\] ( sarouti\[6\] 1018 n480 clockt resetn ) dffsbt
xsarouti_reg\[7\] ( n158 1019 n44 clockt resetn ) dffsbn
xsarouti_reg\[4\] ( sarouti\[4\] 1020 n47 clockt resetn ) dffsbn
xsaroutd_reg\[1\] ( saroutd\[1\] 1021 n52 clockt resetn ) dffsbn
xsarouti_reg\[0\] ( sarouti\[0\] 1022 n51 clockt resetn ) dffsbn
xg1358 ( n54 n41 n250 ) nr2
xsaroutd_reg\[0\] ( saroutd\[0\] 1023 n335 clockt resetn ) dffsbn
xg1361 ( n52 n38 n405 ) nd2
xg1362 ( n51 n320 n39 ) nd2
xg1363 ( n50 n189 n213 n189 sarouti\[1\] ) moai1s
xg1365 ( n48 n189 n369 n189 sarouti\[3\] ) moai1s
xg1366 ( n47 n189 n443 n189 sarouti\[4\] ) moai1s
xg1367 ( n46 n189 sarout\[5\] n189 sarouti\[5\] ) moai1s
xg1369 ( n44 n189 sarout\[7\] n189 n158 ) moai1s
xtemptmr_reg\[1\] ( temptmr\[1\] n36 clockt resetn ) qdffrbn
xg1373 ( n41 temptmr\[2\] n14 ) xor2hs
xg1375 ( n39 n315 n32 n189 sarouti\[0\] ) aoi22s
xg1376 ( n38 n315 n21 n189 saroutd\[1\] ) aoi22s
xg1379 ( n36 n3 n250 ) nr2
xdataout_reg\[0\] ( dataout\[0\] 1024 dataout\[0\] n9 clockt n304 resetn ) dfzsbn
xdataout_reg\[2\] ( dataout\[2\] n368 dataout\[2\] clockt n177 resetn ) qdfzrbn
xdataout_reg\[3\] ( dataout\[3\] n369 dataout\[3\] clockt n177 resetn ) qdfzrbn
xdataout_reg\[4\] ( dataout\[4\] n443 dataout\[4\] clockt n177 resetn ) qdfzrbn
xdataout_reg\[6\] ( dataout\[6\] sarout\[6\] dataout\[6\] clockt n177 resetn ) qdfzrbn
xdataout_reg\[1\] ( dataout\[1\] n213 dataout\[1\] clockt n177 resetn ) qdfzrbn
xdataout_reg\[7\] ( dataout\[7\] sarout\[7\] dataout\[7\] clockt n177 resetn ) qdfzrbn
xdataout_reg\[5\] ( dataout\[5\] sarout\[5\] dataout\[5\] clockt n177 resetn ) qdfzrbn
xtimerout_reg\[0\] ( timerout\[0\] n24 clockt resetn ) qdffrbn
xtimerout_reg\[1\] ( timerout\[1\] n23 clockt resetn ) qdffrbn
xtimerout_reg\[2\] ( timerout\[2\] n22 clockt resetn ) qdffrbn
xtimerout_reg\[3\] ( timerout\[3\] n25 clockt resetn ) qdffrbn
xg1395 ( n32 n437 n27 ) nr2
xg1397 ( n30 n398 ) inv1s
xtemptmr_reg\[0\] ( temptmr\[0\] n0 clockt resetn ) qdffrbp
xg1400 ( n29 n213 sarout\[6\] sarout\[7\] ) nr3
xg1402 ( n27 n16 sarout\[6\] n443 ) nd3
xg1404 ( n25 n250 timerout\[3\] temptmr\[3\] ) mux2
xg1405 ( n24 n250 timerout\[0\] temptmr\[0\] ) mux2
xg1406 ( n23 n250 timerout\[1\] temptmr\[1\] ) mux2
xg1407 ( n22 n250 timerout\[2\] temptmr\[2\] ) mux2
xg1409 ( n21 n251 n213 n251 n213 ) moai1s
xg1411 ( n19 n189 n166 ) nd2s
xg1415 ( n16 n445 n446 ) nr2
xg1416 ( n15 n368 n369 ) nr2
xg1417 ( n14 temptmr\[1\] temptmr\[0\] ) nd2
xg1418 ( n13 n443 sarout\[5\] ) nr2
xg1437 ( n9 n251 ) inv2
xg1438 ( n8 sarout\[0\] ) inv3ck
xg1444 ( n3 temptmr\[1\] temptmr\[0\] ) xnr2hs
xg1445 ( n2 temptmr\[2\] n14 ) an2b1s
xg1447 ( n0 n250 temptmr\[0\] ) or2b1s
xg1450 ( n175 n451 n443 ) xor2hs
xfopt1453 ( n177 n304 ) inv3ck
xfopt1473 ( n214 n213 ) inv1
xfopt1476 ( n213 n218 ) inv2ck
xfopt1477 ( n218 sarout\[1\] ) inv3ck
xg73 ( n236 statep\[0\] ) inv3
xg15 ( n250 n248 n249 ) nd2f
xg17 ( n249 n78 n77 ) or2
xfopt1494 ( n251 n8 ) buf2ck
xg33 ( n273 statep\[1\] ) inv3
xfopt1499 ( saroutc\[7\] n277 ) buf6ck
xg1515 ( n299 n460 n250 ) or2s
xg135 ( n304 n387 ) inv3
xg97 ( n317 n315 sarouti\[2\] n316 ) mux2
xg100 ( n320 n315 n8 ) nd2s
xg98 ( n321 saroutd\[4\] n315 n175 n189 ) oai22s
xg1520 ( n335 n457 n405 ) nd2s
xg86 ( n364 n405 n361 n481 n189 ) oai112h
xg1532 ( n356 n273 n236 ) nd2t
xg94 ( n357 statep\[1\] statep\[0\] ) nd2p
xg88 ( n361 n189 saroutd\[6\] ) nd2s
xg2 ( n368 n316 ) inv2
xg1 ( n369 sarout\[3\] ) buf1
xg27 ( n387 n273 n236 ) nd2t
xg1540 ( n399 n393 n397 n398 ) nr3
xg1541 ( n393 sarout\[6\] sarout\[4\] ) or2
xg1542 ( n397 n316 n446 n445 ) nd3s
xfopt58 ( n316 sarout\[2\] ) inv2
xg55 ( n398 n8 n218 ) nd2t
xg68 ( n406 n436 n405 ) nd2
xg71 ( n402 n452 sarout\[5\] ) xnr2hs
xg1544 ( n405 n454 n29 n13 n15 ) nd4t
xg74 ( n315 n189 ) inv3
xg38 ( n409 reset ) inv1s
xg42 ( n417 n413 n405 n416 ) nd3
xg45 ( n413 n189 saroutd\[2\] ) nd2s
xg43 ( n416 n315 n415 ) nd2s
xg44 ( n415 n30 n368 n30 n368 ) moai1s
xg1548 ( 1025 n411 n273 n435 ) ha3
xflagtmr_reg ( 1026 n432 n299 clockt resetn ) dffrbn
xg10 ( saroutd\[5\] n433 ) inv3
xg1553 ( n435 dcr inc ) or2
xg1554 ( n436 n189 n402 saroutd\[5\] ) mxl2hs
xg1555 ( n437 n214 n368 sarout\[7\] ) or3b2
xg1556 ( n248 n460 n432 ) nd2p
xg1560 ( n443 n442 ) inv2
xg4 ( n442 sarout\[4\] ) inv2
xg40 ( n445 sarout\[3\] ) inv2
xg41 ( n446 sarout\[5\] ) inv2
xg39 ( n447 sarout\[2\] n398 ) nr2p
xg1561 ( n452 n443 n451 ) nr2p
xg1562 ( n451 n447 n445 ) nd2p
xg1563 ( n453 sarout\[2\] n398 ) nr2
xg28 ( n457 saroutd\[0\] n454 n189 n9 ) oai22s
xg30 ( n189 n454 ) inv8
xg31 ( n454 n356 n357 ) nd2t
xg21 ( n460 resetp n459 n411 ) aoi12h
xg22 ( n459 n356 n357 ) nd2t
xg1579 ( n480 n189 n110 sarouti\[6\] ) mux2
xg1580 ( n481 sarout\[6\] n482 ) xor2hs
xg1581 ( n482 n442 n445 n446 n447 ) an4
xg1590 ( n494 n387 n435 n409 ) aoi12s
ends sartimer4verilog
