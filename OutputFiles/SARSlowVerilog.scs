// $ Spice netlist generated by v2lvs
simulator lang=spectre insensitive=yes
//  v2011.1_15.11    thu feb 10 17:20:50 pst 2011
//  global 0 gnd vcc
//  aliasGnd ( gnd 0 ) vsource type=dc dc=0
include "/Cad/DesignK/FaradayUMC180/DigitalCore/BackEnd/lvs/fsa0a_c_generic_core.scs"

subckt sarslowverilog ( clock reset inc dcr compare clockcmp statep\[1\] statep\[0\]
+ sarout\[7\] sarout\[6\] sarout\[5\] sarout\[4\] sarout\[3\] sarout\[2\] sarout\[1\]
+ sarout\[0\] )
xg2206 ( n158 n168 ) inv1s
xg2207 ( n157 n169 ) inv1s
xg2205 ( n156 n171 ) inv1s
xg2204 ( n155 n181 ) inv1s
xg2208 ( n154 n170 ) inv1s
xg2209 ( n182 statep\[1\] statep\[0\] ) nr2
xg2463 ( sarout\[0\] reset n153 ) nr2
xg2464 ( n184 n153 ) inv1s
xg2465 ( n153 sar\[0\] tempsar\[0\] ) nr2
xsar_reg\[0\] ( sar\[0\] n152 clock n12 ) qdffrbs
xg2467 ( n152 n162 setsar\[0\] sar\[1\] statep\[1\] ) ao22
xg2469 ( n162 n167 n165 n185 ) an3
xg2470 ( sarout\[4\] n171 n12 ) an2
xg2471 ( sarout\[7\] n168 n12 ) an2
xg2472 ( sarout\[6\] n169 n12 ) an2
xg2473 ( sarout\[3\] n172 n12 ) an2
xg2474 ( sarout\[5\] n170 n12 ) an2
xg2475 ( sarout\[2\] n181 n12 ) an2
xg2476 ( sarout\[1\] n183 n12 ) an2
xg2477 ( n167 n186 n187 ) or2
xg2478 ( clockcmp clock n182 reset ) nr3
xg2479 ( n185 checkid\[0\] compare checkid\[0\] compare ) moai1s
xg2480 ( n186 checkid\[0\] n150 ) nr2
xg2481 ( n187 n150 checkid\[0\] ) an2
xg2483 ( n183 tempsar\[1\] sar\[1\] ) or2
xg2484 ( n170 tempsar\[5\] sar\[5\] ) or2
xg2485 ( n171 tempsar\[4\] sar\[4\] ) or2
xg2486 ( n168 tempsar\[7\] sar\[7\] ) or2
xg2487 ( n172 tempsar\[3\] sar\[3\] ) or2
xg2488 ( n169 tempsar\[6\] sar\[6\] ) or2
xg2489 ( n181 tempsar\[2\] sar\[2\] ) or2
xg2490 ( n12 reset ) inv1s
xg2 ( n165 statep\[0\] statep\[1\] ) an2b1s
xg4010 ( n149 n28 n124 n145 n1 n62 n158 ) oai222s
xstatep_reg\[1\] ( statep\[1\] 1000 n147 clock n12 ) dffsbn
xg4014 ( n148 n14 n144 n114 n28 n62 n157 ) oai222s
xsetsar_reg\[7\] ( setsar\[7\] n143 clock n12 ) qdffrbn
xg4017 ( n147 n132 n140 n198 ) nd3
xg4018 ( n146 n0 n139 n104 n28 n62 n154 ) oai222s
xg4019 ( n145 n136 n138 compare setsar\[6\] ) aoi112s
xsetsar_reg\[5\] ( setsar\[5\] n135 clock n12 ) qdffrbn
xg4023 ( n144 n138 n115 n116 n8 ) aoi13hs
xg4024 ( n143 n128 n129 n19 ) nd3
xg4025 ( n142 n4 n131 n90 n28 n62 n156 ) oai222s
xsetsar_reg\[6\] ( setsar\[6\] n127 clock n12 ) qdffrbn
xtempsar_reg\[1\] ( tempsar\[1\] n134 clock n12 ) qdffrbn
xg4028 ( n141 n133 n78 n74 n28 ) oai112s
xg4029 ( n140 n165 n118 n44 ) oai12s
xg4030 ( n139 n130 n105 n106 compare ) oa13s
xg4031 ( n138 n130 n76 ) nd2
xg4032 ( n137 n9 n117 n59 n28 n62 n155 ) oai222s
xg4033 ( n136 n126 n8 n116 setsar\[6\] ) oa112
xg4034 ( n135 n108 n123 n31 ) nd3
xsetsar_reg\[3\] ( setsar\[3\] n120 clock n12 ) qdffrbn
xsetsar_reg\[4\] ( setsar\[4\] n122 clock n12 ) qdffrbn
xg4037 ( n134 n183 n63 n112 tempsar\[1\] n25 n29 ) ao222
xg4038 ( n133 tempsar\[3\] n110 n101 ) oai12s
xg4039 ( n132 n8 n1 n124 ) or3
xg4040 ( n131 n121 n92 n87 n8 ) aoi13hs
xg4041 ( n130 n121 compare setsar\[4\] ) aoi12s
xg4042 ( n129 n125 n16 tempsar\[7\] ) nd3
xg4043 ( n128 tempsar\[7\] n18 n124 ) or3
xg4044 ( n127 n119 n99 n32 ) nd3
xstatep_reg\[0\] ( statep\[0\] 1001 n113 clock n12 ) dffsbn
xsetsar_reg\[0\] ( setsar\[0\] n107 clock n12 ) qdffrbn
xsetsar_reg\[2\] ( setsar\[2\] n109 clock n12 ) qdffrbn
xg4049 ( n126 n125 ) inv1s
xg4050 ( n125 tempsar\[6\] n115 ) nr2
xg4051 ( n124 n14 n114 ) or2
xg4052 ( n123 n105 n16 tempsar\[5\] ) nd3
xg4053 ( n122 n85 n96 n39 ) nd3
xg4054 ( n121 n110 compare setsar\[3\] ) ao12
xg4055 ( n120 n95 n100 n35 ) nd3
xg4056 ( n119 tempsar\[6\] n46 n114 ) or3
xg4057 ( n118 compare n192 n186 n8 ) oai22s
xg4058 ( n117 n103 n97 n26 n65 ) aoi112s
xsetsar_reg\[1\] ( setsar\[1\] n102 clock n12 ) qdffrbn
xg4060 ( n116 setsar\[5\] n106 ) or2b1s
xg4061 ( n115 n105 n0 ) nd2
xg4062 ( n114 n0 n104 ) or2
xg4063 ( n113 n94 n199 n13 ) oai12s
xg4064 ( n112 n97 n93 ) or2
xg4065 ( n111 n201 n82 n24 n167 ) oai112s
xg4066 ( n110 n97 n66 compare ) ao12
xg4067 ( n109 n70 n86 n21 ) nd3
xg4068 ( n108 tempsar\[5\] n18 n104 ) or3
xg4069 ( n107 n84 n6 n162 setsar\[0\] ) moai1s
xg4072 ( n106 setsar\[4\] n87 ) nr2
xg4073 ( n105 tempsar\[4\] n92 ) nr2
xg4074 ( n104 n4 n90 ) or2
xg4075 ( n103 n40 n194 ) nr2
xg4076 ( n102 n69 n20 n17 n49 ) oai112s
xg4077 ( n101 n77 n193 ) nr2
xg4078 ( n100 n16 n77 tempsar\[3\] ) nd3
xg4079 ( n99 n47 n71 tempsar\[6\] ) nd3
xg4082 ( n96 tempsar\[4\] n46 n90 ) or3
xg4083 ( n95 tempsar\[3\] n74 n18 ) or3
xg4084 ( n94 n91 reset n13 n54 ) aoi112s
xg4085 ( n93 n67 compare compare setsar\[0\] ) moai1s
xsar_reg\[7\] ( sar\[7\] n75 clock n12 ) qdffrbn
xg4087 ( n92 n77 n11 ) nd2
xg4088 ( n91 sar\[5\] sar\[7\] n64 sar\[6\] sar\[4\] n45 ) nr6
xg4089 ( n90 n11 n74 ) or2
xg4092 ( n87 setsar\[3\] n66 n2 ) or3
xg4093 ( n86 tempsar\[2\] n59 n46 ) or3
xg4094 ( n85 n47 n51 tempsar\[4\] ) nd3
xg4095 ( n84 n48 n3 n25 checkid\[0\] ) aoi13hs
xg4097 ( n82 n63 n184 n200 tempsar\[0\] ) aoi22s
xg4098 ( n81 n64 n150 n182 inc ) moai1s
xg4100 ( n79 n64 n7 n182 dcr ) moai1s
xsar_reg\[4\] ( sar\[4\] n58 clock n12 ) qdffrbn
xsar_reg\[5\] ( sar\[5\] n57 clock n12 ) qdffrbn
xsar_reg\[6\] ( sar\[6\] n56 clock n12 ) qdffrbn
xsar_reg\[3\] ( sar\[3\] n52 clock n12 ) qdffrbn
xsar_reg\[1\] ( sar\[1\] n53 clock n12 ) qdffrbn
xsar_reg\[2\] ( sar\[2\] n55 clock n12 ) qdffrbn
xg4107 ( n78 n172 n63 ) nd2s
xg4108 ( n77 tempsar\[2\] n65 ) nr2
xg4109 ( n76 compare setsar\[5\] ) nd2
xg4110 ( n75 setsar\[7\] n185 n165 n6 ) an4b1s
xg4111 ( n74 n9 n59 ) or2
xg4114 ( n71 n51 n4 n0 ) an3
xg4115 ( n70 n47 n38 tempsar\[2\] ) nd3
xg4116 ( n69 tempsar\[1\] n24 n18 ) or3
xg4118 ( n67 n30 n10 n187 tempsar\[0\] ) aoi22s
xg4119 ( n66 setsar\[2\] n40 ) or2b1s
xg4120 ( n65 n187 n38 ) nd2
xg4121 ( n64 n43 n165 ) nr2
xg4122 ( n62 n63 ) inv1s
xg4123 ( n63 n43 compare ) an2
xg4126 ( n59 n25 tempsar\[1\] ) nd2
xg4127 ( n58 n39 n37 ) nd2
xg4128 ( n57 n31 n41 ) nd2
xg4129 ( n56 n32 n34 ) nd2
xg4130 ( n55 n21 n42 ) nd2
xg4131 ( n54 n23 statep\[1\] ) nr2
xg4132 ( n53 n20 n27 ) nd2
xg4133 ( n52 n35 n36 ) nd2
xg4134 ( n51 n38 n11 n9 ) an3
xg4136 ( n49 n187 n15 tempsar\[1\] ) nd3
xg4137 ( n48 checkid\[0\] tempsar\[0\] n17 ) nr3
xg4138 ( n47 checkid\[1\] n7 n17 ) nr3
xg4139 ( n46 n3 n7 checkid\[1\] ) nd3
xg4140 ( n45 sar\[1\] n33 sar\[0\] ) or3b2
xg4141 ( n44 n187 n8 n10 compare ) aoi22s
xg4142 ( n43 statep\[1\] statep\[0\] ) an2b1s
xg4143 ( n42 sar\[3\] statep\[1\] ) nd2s
xg4144 ( n41 sar\[6\] statep\[1\] ) nd2s
xg4145 ( n40 setsar\[0\] setsar\[1\] ) nr2
xg4146 ( n39 n162 setsar\[4\] ) nd2s
xg4147 ( n38 tempsar\[0\] tempsar\[1\] ) nr2
xg4148 ( n37 sar\[5\] statep\[1\] ) nd2s
xg4149 ( n36 sar\[4\] statep\[1\] ) nd2s
xg4150 ( n35 n162 setsar\[3\] ) nd2s
xg4151 ( n34 sar\[7\] statep\[1\] ) nd2s
xg4152 ( n33 sar\[2\] sar\[3\] ) nr2
xg4153 ( n32 n162 setsar\[6\] ) nd2s
xg4154 ( n31 n162 setsar\[5\] ) nd2s
xg4155 ( n30 setsar\[0\] n2 ) or2
xg4156 ( n28 n29 ) inv1s
xg4157 ( n29 n8 n2 ) nr2
xg4158 ( n27 sar\[2\] statep\[1\] ) nd2s
xg4159 ( n26 compare n186 ) nr2
xg4160 ( n24 n25 ) inv1s
xg4161 ( n25 n15 n13 ) nr2
xg4162 ( n23 dcr inc ) nr2
xg4164 ( n21 n162 setsar\[2\] ) nd2s
xg4165 ( n20 n162 setsar\[1\] ) nd2s
xg4166 ( n19 n162 setsar\[7\] ) nd2s
xg4167 ( n18 n3 n186 ) nd2
xg4168 ( n16 n17 ) inv1s
xg4169 ( n17 n3 n165 ) nd2
xg4186 ( n13 n165 ) inv1s
xg4202 ( n10 n187 ) inv1s
xg4212 ( n8 compare ) inv1s
xg4217 ( n6 n167 ) inv1s
xg4234 ( n3 n162 ) inv1s
xg4235 ( n2 n186 ) inv1s
xg4257 ( n192 n71 n1 n14 ) nd3
xg4258 ( n193 n26 n66 ) nr2
xg4259 ( n194 compare n65 ) nr2
xg4261 ( n97 n165 n8 n187 ) oai12s
xg4262 ( n197 n165 n6 n185 ) oa12s
xg4263 ( n198 reset n43 ) nr2
xg4264 ( n199 n44 n26 ) an2b1s
xg4265 ( n200 n182 statep\[1\] ) or2
xcheckid_reg\[1\] ( checkid\[1\] n150 n81 clock n12 ) dffrbn
xtempsar_reg\[0\] ( tempsar\[0\] n15 n111 clock n12 ) dffrbn
xtempsar_reg\[6\] ( tempsar\[6\] n14 n148 clock n12 ) dffrbn
xtempsar_reg\[3\] ( tempsar\[3\] n11 n141 clock n12 ) dffrbn
xtempsar_reg\[2\] ( tempsar\[2\] n9 n137 clock n12 ) dffrbn
xcheckid_reg\[0\] ( checkid\[0\] n7 n79 clock n12 ) dffrbn
xtempsar_reg\[4\] ( tempsar\[4\] n4 n142 clock n12 ) dffrbn
xtempsar_reg\[7\] ( tempsar\[7\] n1 n149 clock n12 ) dffrbn
xtempsar_reg\[5\] ( tempsar\[5\] n0 n146 clock n12 ) dffrbn
xg4284 ( n201 n197 statep\[0\] compare ) or3b2
ends sarslowverilog
