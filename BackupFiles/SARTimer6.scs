// $ Spice netlist generated by v2lvs
simulator lang=spectre insensitive=yes
//  v2011.1_15.11    thu feb 10 17:20:50 pst 2011
global 0 gnd vcc
aliasGnd ( gnd 0 ) vsource type=dc dc=0
include "/Cad/DesignK/FaradayUMC180/DigitalCore/BackEnd/lvs/fsa0a_c_generic_core.spi"

subckt sartimerverilog_timer6 ( reset clockt statep\[1\] statep\[0\] inc dcr ready
+ timerout\[5\] timerout\[4\] timerout\[3\] timerout\[2\] timerout\[1\] timerout\[0\]
+ flagconv )
xtimerout_reg\[0\] ( timerout\[0\] n46 clockt n47 ) qdffrbs
xtimerout_reg\[1\] ( timerout\[1\] n43 clockt n47 ) qdffrbs
xtimerout_reg\[2\] ( timerout\[2\] n45 clockt n47 ) qdffrbs
xtimerout_reg\[3\] ( timerout\[3\] n41 clockt n47 ) qdffrbs
xtimerout_reg\[4\] ( timerout\[4\] n42 clockt n47 ) qdffrbs
xtimerout_reg\[5\] ( timerout\[5\] n40 clockt n47 ) qdffrbs
xflagtmr_reg ( flagtmr n39 clockt n47 ) qdffrbn
xg627 ( n46 n44 n13 n5 ) mxl2hs
xg629 ( n45 n44 n18 n3 ) mxl2hs
xg628 ( n43 n44 n12 n2 ) mxl2hs
xg631 ( n42 n44 n24 n0 ) mxl2hs
xg630 ( n41 n44 n26 n4 ) mxl2hs
xg632 ( n40 n44 n1 n6 ) mxl2hs
xtemptmr_reg\[3\] ( temptmr\[3\] n60 clockt n47 ) qdffrbn
xtemptmr_reg\[4\] ( temptmr\[4\] n62 clockt n47 ) qdffrbp
xtemptmr_reg\[2\] ( temptmr\[2\] n61 clockt n47 ) qdffrbn
xtemptmr_reg\[5\] ( temptmr\[5\] n35 clockt n47 ) qdffrbn
xtemptmr_reg\[1\] ( temptmr\[1\] n37 clockt n47 ) qdffrbp
xtemptmr_reg\[0\] ( temptmr\[0\] n38 clockt n47 ) qdffrbp
xg636 ( n39 n44 n28 ) nd2
xg637 ( n38 temptmr\[0\] n36 ) nr2
xg638 ( n37 n14 n36 ) nr2
xg639 ( n35 n63 n36 ) nr2
xready_reg ( ready n36 clockt n47 ) qdffrbs
xg641 ( n44 n36 ) inv4
xg642 ( n36 n22 n30 ) nd2f
xg646 ( n30 flagtmr n28 ) or2p
xg650 ( flagconv n28 ) inv1s
xg644 ( n22 n21 temptmr\[4\] temptmr\[5\] ) nd3p
xg651 ( n28 n15 n11 ) nd2p
xg647 ( n17 n18 n16 ) nr2
xg652 ( n15 n9 n10 ) nd2p
xg654 ( n21 n7 n8 ) nr2f
xg655 ( n14 n13 temptmr\[1\] n12 temptmr\[0\] ) aoi22s
xg653 ( n11 reset statep\[0\] statep\[1\] ) aoi12s
xg656 ( n10 dcr inc ) nr2p
xg658 ( n9 statep\[0\] statep\[1\] ) nr2p
xg660 ( n16 temptmr\[1\] temptmr\[0\] ) nd2
xg659 ( n8 temptmr\[1\] temptmr\[3\] ) nd2p
xg657 ( n7 temptmr\[0\] temptmr\[2\] ) nd2p
xg663 ( n47 reset ) inv1s
xg668 ( n26 temptmr\[3\] ) inv1s
xg664 ( n18 temptmr\[2\] ) inv1s
xg669 ( n13 temptmr\[0\] ) inv1s
xg661 ( n6 timerout\[5\] ) inv1s
xg672 ( n5 timerout\[0\] ) inv1s
xg666 ( n4 timerout\[3\] ) inv1s
xg665 ( n3 timerout\[2\] ) inv1s
xg662 ( n12 temptmr\[1\] ) inv1s
xg667 ( n2 timerout\[1\] ) inv1s
xg671 ( n24 temptmr\[4\] ) inv1s
xg673 ( n1 temptmr\[5\] ) inv1s
xg670 ( n0 timerout\[4\] ) inv1s
xg2 ( n60 n17 temptmr\[3\] n26 n36 ) muxb2
xg688 ( n61 n16 n18 temptmr\[2\] n36 ) muxb2
xg689 ( n62 n21 temptmr\[4\] n24 n36 ) muxb2
xg690 ( n63 temptmr\[5\] n21 temptmr\[4\] ) aoi12s
ends sartimerverilog_timer6
