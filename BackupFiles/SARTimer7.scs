// $ Spice netlist generated by v2lvs
simulator lang=spectre insensitive=yes
//  v2011.1_15.11    thu feb 10 17:20:50 pst 2011
global 0 gnd vcc
aliasGnd ( gnd 0 ) vsource type=dc dc=0
include "/Cad/DesignK/FaradayUMC180/DigitalCore/BackEnd/lvs/fsa0a_c_generic_core.spi"

subckt sartimerverilog_timer7 ( reset clockt statep\[1\] statep\[0\] inc dcr ready
+ timerout\[6\] timerout\[5\] timerout\[4\] timerout\[3\] timerout\[2\] timerout\[1\]
+ timerout\[0\] flagconv )
xtimerout_reg\[0\] ( timerout\[0\] n49 clockt n55 ) qdffrbs
xtimerout_reg\[1\] ( timerout\[1\] n48 clockt n55 ) qdffrbs
xtimerout_reg\[2\] ( timerout\[2\] n47 clockt n55 ) qdffrbs
xtimerout_reg\[3\] ( timerout\[3\] n54 clockt n55 ) qdffrbs
xtimerout_reg\[4\] ( timerout\[4\] n53 clockt n55 ) qdffrbs
xtimerout_reg\[5\] ( timerout\[5\] n51 clockt n55 ) qdffrbs
xtimerout_reg\[6\] ( timerout\[6\] n50 clockt n55 ) qdffrbs
xtemptmr_reg\[2\] ( temptmr\[2\] n43 clockt n55 ) qdffrbn
xtemptmr_reg\[1\] ( temptmr\[1\] n41 clockt n55 ) qdffrbn
xtemptmr_reg\[0\] ( temptmr\[0\] n42 clockt n55 ) qdffrbp
xtemptmr_reg\[6\] ( temptmr\[6\] n45 clockt n55 ) qdffrbn
xtemptmr_reg\[5\] ( temptmr\[5\] n44 clockt n55 ) qdffrbp
xtemptmr_reg\[4\] ( temptmr\[4\] n40 clockt n55 ) qdffrbn
xtemptmr_reg\[3\] ( temptmr\[3\] n46 clockt n55 ) qdffrbp
xg709 ( n54 n52 n7 n14 ) mxl2hs
xflagtmr_reg ( flagtmr n39 clockt n55 ) qdffrbn
xg710 ( n53 n52 n6 n33 ) mxl2hs
xg711 ( n51 n52 n2 n0 ) mxl2hs
xg712 ( n50 n52 n4 n8 ) mxl2hs
xg706 ( n49 n52 n1 n18 ) mxl2hs
xg707 ( n48 n52 n5 n17 ) mxl2hs
xg708 ( n47 n52 n3 n24 ) mxl2hs
xready_reg ( ready n52 clockt n55 ) qdffrbs
xg692 ( n46 n27 n52 ) nr2
xg684 ( n45 n52 n37 ) nr2
xg685 ( n44 n52 n36 ) nr2
xg714 ( n43 n25 n52 ) nr2
xg716 ( n42 temptmr\[0\] n52 ) nr2
xg718 ( n41 n19 n52 ) nr2
xg689 ( n40 n34 n52 ) nr2
xg717 ( n39 n69 n29 ) nd2
xg719 ( n52 n69 ) inv6
xg686 ( n37 temptmr\[6\] n35 temptmr\[5\] ) aoi12s
xg688 ( n36 temptmr\[5\] n35 ) xnr2hs
xg691 ( n34 temptmr\[4\] n32 ) xor2hs
xg693 ( n35 n33 n32 ) nr2p
xg725 ( flagconv n29 ) inv1s
xg705 ( n27 n26 temptmr\[3\] ) xnr2hs
xg715 ( n32 n26 temptmr\[3\] ) nd2p
xg726 ( n29 n21 n15 ) nd2p
xg721 ( n25 n23 temptmr\[2\] n24 ) mux2
xg723 ( n26 n24 n23 ) nr2t
xg724 ( n22 n11 n23 ) nr2p
xg727 ( n21 n9 n10 ) nd2
xg728 ( n20 n16 ) inv2
xg731 ( n19 n18 temptmr\[1\] n17 temptmr\[0\] ) aoi22s
xg729 ( n16 temptmr\[6\] temptmr\[2\] temptmr\[5\] ) nd3
xg730 ( n15 reset statep\[0\] statep\[1\] ) aoi12s
xg737 ( n14 temptmr\[3\] ) inv1s
xg733 ( n23 temptmr\[1\] temptmr\[0\] ) nd2p
xg735 ( n11 temptmr\[4\] temptmr\[3\] ) nd2
xg732 ( n10 dcr inc ) nr2
xg734 ( n9 statep\[0\] statep\[1\] ) nr2
xg740 ( n18 temptmr\[0\] ) inv1s
xg743 ( n8 temptmr\[6\] ) inv1s
xg736 ( n24 temptmr\[2\] ) inv2
xg752 ( n7 timerout\[3\] ) inv1s
xg751 ( n6 timerout\[4\] ) inv1s
xg742 ( n33 temptmr\[4\] ) inv1s
xg746 ( n5 timerout\[1\] ) inv1s
xg741 ( n4 timerout\[6\] ) inv1s
xg748 ( n3 timerout\[2\] ) inv1s
xg749 ( n2 timerout\[5\] ) inv1s
xg750 ( n1 timerout\[0\] ) inv1s
xg744 ( n55 reset ) inv1s
xg747 ( n17 temptmr\[1\] ) inv1s
xg745 ( n0 temptmr\[5\] ) inv1s
xg2 ( n69 n22 n20 flagtmr n29 ) maoi1hp
ends sartimerverilog_timer7
