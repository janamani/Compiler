// $ Spice netlist generated by v2lvs
simulator lang=spectre insensitive=yes
//  v2011.1_15.11    thu feb 10 17:20:50 pst 2011
//  global 0 gnd vcc
//  aliasGnd ( gnd 0 ) vsource type=dc dc=0
include "/Cad/DesignK/FaradayUMC180/DigitalCore/BackEnd/lvs/fsa0a_c_generic_core.scs"

subckt sartimer4verilog ( statep\[1\] statep\[0\] sarout\[7\] sarout\[6\] sarout\[5\]
+ sarout\[4\] sarout\[3\] sarout\[2\] sarout\[1\] sarout\[0\] clockt reset inc dcr
+ ready resetp resetn saroutis saroutds saroutig saroutdg saroutcg clockdcr clockinc
+ clocktck dataout\[7\] dataout\[6\] dataout\[5\] dataout\[4\] dataout\[3\] dataout\[2\]
+ dataout\[1\] dataout\[0\] timerout\[3\] timerout\[2\] timerout\[1\] timerout\[0\]
+ sarouti\[7\] sarouti\[6\] sarouti\[5\] sarouti\[4\] sarouti\[3\] sarouti\[2\]
+ sarouti\[1\] sarouti\[0\] saroutd\[7\] saroutd\[6\] saroutd\[5\] saroutd\[4\]
+ saroutd\[3\] saroutd\[2\] saroutd\[1\] saroutd\[0\] saroutc\[7\] saroutc\[6\]
+ saroutc\[5\] saroutc\[4\] saroutc\[3\] saroutc\[2\] saroutc\[1\] saroutc\[0\]
+ )

xdataout_reg\[7\] ( dataout\[7\] sarout\[7\] dataout\[7\] clockt n101 resetn ) qdfzrbn
xdataout_reg\[6\] ( dataout\[6\] sarout\[6\] dataout\[6\] clockt n101 resetn ) qdfzrbn
xdataout_reg\[5\] ( dataout\[5\] sarout\[5\] dataout\[5\] clockt n101 resetn ) qdfzrbn
xdataout_reg\[4\] ( dataout\[4\] sarout\[4\]	dataout\[4\] clockt n101 resetn ) qdfzrbn
xdataout_reg\[3\] ( dataout\[3\] sarout\[3\]	dataout\[3\] clockt n101 resetn ) qdfzrbn
xdataout_reg\[2\] ( dataout\[2\] sarout\[2\]	dataout\[2\] clockt n101 resetn ) qdfzrbn
xdataout_reg\[1\] ( dataout\[1\] sarout\[1\]	dataout\[1\] clockt n101 resetn ) qdfzrbn
xdataout_reg\[0\] ( dataout\[0\] sarout\[0\]	dataout\[0\] clockt n101 resetn ) qdfzrbn
xg101 ( n101 n102 ) inv3ck
xg102 ( n102 n103 ) inv3
xg103 ( n104 statep\[1\] ) inv3
xg104 ( n105 statep\[0\] ) inv3
xg105 ( n103 n104 n105 ) nd2t

xg201 ( saroutcg resetn ) buf2
xg202 ( saroutdg resetn ) buf2
xg203 ( saroutig resetn ) buf2
xg204 ( saroutds saroutis ) buf2
xg205 ( saroutis resetp ) buf2
xg206 ( resetp reset ) buf2
xg207 ( resetn resetp ) inv2

xg300 ( clocktck clockdcr ) buf2
xg301 ( clockinc clockdcr ) buf2
xg302 ( resetp reset ) buf2
xg303 ( clockdcr clockt resetp n301 ) nr3t
xg304 ( n301 n302 n304 ) nr2
xg305 ( n302 n303 ) inv1s
xg306 ( n303 statep\[1\] statep\[0\] ) nd2p
xg307 ( n304 n305 n308 n309 ) aoi12s
xg308 ( n305 n306 n307 ) nd2t
xg309 ( n306 statep\[1\] ) inv3
xg310 ( n307 statep\[0\] ) inv3
xg311 ( n308 dcr inc ) or2
xg312 ( n309 reset ) inv1s

xsaroutc_reg\[7\] ( n401         1001 n402 clockt resetn ) dffsbn
xsaroutc_reg\[6\] ( saroutc\[6\] 1002 n403 clockt resetn ) dffsbn
xsaroutc_reg\[5\] ( saroutc\[5\] 1003 n404 clockt resetn ) dffsbn
xsaroutc_reg\[4\] ( saroutc\[4\] 1004 n405 clockt resetn ) dffsbn
xsaroutc_reg\[3\] ( saroutc\[3\] 1005 n406 clockt resetn ) dffsbn
xsaroutc_reg\[2\] ( saroutc\[2\] 1006 n407 clockt resetn ) dffsbn
xsaroutc_reg\[1\] ( saroutc\[1\] 1007 n408 clockt resetn ) dffsbn
xsaroutc_reg\[0\] ( saroutc\[0\] 1008 n409 clockt resetn ) dffsbn
xg401 ( saroutc\[7\] n401 ) buf6ck
xg402 ( n402 sarout\[7\] ) inv2
xg403 ( n403 sarout\[6\] ) inv2
xg404 ( n404 sarout\[5\] ) inv2
xg405 ( n405 sarout\[4\] ) inv2
xg406 ( n406 sarout\[3\] ) inv2
xg407 ( n407 sarout\[2\] ) inv2
xg408 ( n408 sarout\[1\] ) inv2
xg409 ( n409 sarout\[0\] ) inv2

ends sartimer4verilog
