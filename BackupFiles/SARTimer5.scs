// $ Spice netlist generated by v2lvs
simulator lang=spectre insensitive=yes
//  v2011.1_15.11    thu feb 10 17:20:50 pst 2011
global 0 gnd vcc
aliasGnd ( gnd 0 ) vsource type=dc dc=0
include "/Cad/DesignK/FaradayUMC180/DigitalCore/BackEnd/lvs/fsa0a_c_generic_core.spi"

subckt sartimerverilog_timer5 ( reset clockt statep\[1\] statep\[0\] inc dcr ready
+ timerout\[4\] timerout\[3\] timerout\[2\] timerout\[1\] timerout\[0\] flagconv
+ )
xtimerout_reg\[0\] ( timerout\[0\] n35 clockt n41 ) qdffrbs
xtimerout_reg\[1\] ( timerout\[1\] n39 clockt n41 ) qdffrbs
xtimerout_reg\[2\] ( timerout\[2\] n40 clockt n41 ) qdffrbs
xtimerout_reg\[3\] ( timerout\[3\] n37 clockt n41 ) qdffrbs
xtimerout_reg\[4\] ( timerout\[4\] n36 clockt n41 ) qdffrbs
xflagtmr_reg ( flagtmr n34 clockt n41 ) qdffrbs
xg541 ( n40 n38 n15 n0 ) mxl2hs
xg540 ( n39 n38 n10 n4 ) mxl2hs
xg542 ( n37 n38 n25 n5 ) mxl2hs
xg543 ( n36 n38 n7 n3 ) mxl2hs
xg544 ( n35 n38 n11 n2 ) mxl2hs
xtemptmr_reg\[2\] ( temptmr\[2\] n54 clockt n41 ) qdffrbn
xtemptmr_reg\[3\] ( temptmr\[3\] n53 clockt n41 ) qdffrbn
xtemptmr_reg\[4\] ( temptmr\[4\] n28 clockt n41 ) qdffrbn
xtemptmr_reg\[1\] ( temptmr\[1\] n29 clockt n41 ) qdffrbp
xtemptmr_reg\[0\] ( temptmr\[0\] n30 clockt n41 ) qdffrbp
xg548 ( n34 n38 n23 ) nd2
xready_reg ( ready n32 clockt n41 ) qdffrbs
xg549 ( n30 temptmr\[0\] n32 ) nr2
xg550 ( n29 n12 n32 ) nr2
xg551 ( n28 n22 n32 ) nr2
xg552 ( n38 n32 ) inv4
xg553 ( n32 n18 n24 ) nd2f
xg560 ( n24 flagtmr n23 ) or2
xg555 ( n22 temptmr\[4\] n17 temptmr\[3\] ) aoi12s
xg562 ( flagconv n23 ) inv1s
xg563 ( n23 n13 n9 ) nd2p
xg554 ( n18 n17 temptmr\[4\] temptmr\[3\] ) nd3p
xg561 ( n17 n15 n14 ) nr2p
xg564 ( n13 n8 n6 n1 ) nd3p
xg566 ( n12 n11 temptmr\[1\] n10 temptmr\[0\] ) aoi22s
xg565 ( n9 reset statep\[0\] statep\[1\] ) aoi12s
xg567 ( n8 dcr inc ) nr2p
xg568 ( n14 temptmr\[1\] temptmr\[0\] ) nd2p
xg573 ( n7 temptmr\[4\] ) inv1s
xg581 ( n6 statep\[0\] ) inv2
xg572 ( n5 timerout\[3\] ) inv1s
xg570 ( n4 timerout\[1\] ) inv1s
xg577 ( n25 temptmr\[3\] ) inv1s
xg575 ( n3 timerout\[4\] ) inv1s
xg580 ( n2 timerout\[0\] ) inv1s
xg578 ( n10 temptmr\[1\] ) inv1s
xg579 ( n1 statep\[1\] ) inv1
xg574 ( n11 temptmr\[0\] ) inv1s
xg569 ( n0 timerout\[2\] ) inv1s
xg576 ( n15 temptmr\[2\] ) inv2
xg571 ( n41 reset ) inv1s
xg2 ( n53 n17 temptmr\[3\] n25 n32 ) muxb2
xg594 ( n54 n14 n15 temptmr\[2\] n32 ) muxb2
ends sartimerverilog_timer5
