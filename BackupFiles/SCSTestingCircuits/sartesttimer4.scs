// $ Spice netlist generated by v2lvs
simulator lang=spectre insensitive=yes
//  v2011.1_15.11    thu feb 10 17:20:50 pst 2011
//  global 0 gnd vcc
//  aliasGnd ( gnd 0 ) vsource type=dc dc=0
include "/Cad/DesignK/FaradayUMC180/DigitalCore/BackEnd/lvs/fsa0a_c_generic_core.scs"

subckt sartesttimer4 ( statep\[1\] statep\[0\] clockt reset inc dcr
+ ready timerout\[3\] timerout\[2\] timerout\[1\] timerout\[0\]
+ temptmr\[3\] temptmr\[2\] temptmr\[1\] temptmr\[0\] )

xtimerout_reg\[3\] ( timerout\[3\] n702 clockt n701 ) qdffrbs
xtimerout_reg\[2\] ( timerout\[2\] n703 clockt n701 ) qdffrbs
xtimerout_reg\[1\] ( timerout\[1\] n704 clockt n701 ) qdffrbs
xtimerout_reg\[0\] ( timerout\[0\] n705 clockt n701 ) qdffrbs
xg701 ( n701 reset ) inv1s
xg702 ( n702 n706 n707 n708 ) mxl2hs
xg703 ( n706 n709 n710 ) nd2t
xg704 ( n709 n711 temptmr\[3\] ) nd2p
xg705 ( n711 n712 n713 ) nr2p
xg706 ( n712 temptmr\[2\] ) inv2
xg707 ( n713 temptmr\[1\] temptmr\[0\] ) nd2
xg708 ( n710 flagtmr n714 ) or2
xg709 ( n714 n715 n716 ) nd2p
xg710 ( n715 n717 n718 ) nd2
xg711 ( n717 statep\[0\] statep\[1\] ) nr2
xg712 ( n718 inc dcr ) nr2
xg713 ( n716 reset statep\[0\] statep\[1\] ) aoi12s
xg714 ( n707 timerout\[3\] ) inv1s
xg715 ( n708 temptmr\[3\] ) inv1s

xg716 ( n703 n706 n719 n712 ) mxl2hs
xg717 ( n719 timerout\[2\] ) inv1s

xg718 ( n704 n706 n720 n721 ) mxl2hs
xg719 ( n720 timerout\[1\] ) inv1s
xg720 ( n721 temptmr\[1\] ) inv1s

xg721 ( n705 n706 n722 n723 ) mxl2hs
xg722 ( n722 timerout\[0\] ) inv1s
xg723 ( n723 temptmr\[0\] ) inv1s

xtemptmr_reg\[3\] ( temptmr\[3\] n724 clockt n701 ) qdffrbn
xtemptmr_reg\[2\] ( temptmr\[2\] n725 clockt n701 ) qdffrbn
xtemptmr_reg\[1\] ( temptmr\[1\] n726 clockt n701 ) qdffrbp
xtemptmr_reg\[0\] ( temptmr\[0\] n727 clockt n701 ) qdffrbp

xg724 ( n724 n706 n728 n708 ) aoi12s
xg725 ( n728 n711 ) inv1s

xg726 ( n725 n713 n712 temptmr\[2\] n706 ) muxb2
xg727 ( n726 temptmr\[0\] temptmr\[1\] n721 n706 ) muxb2
xg728 ( n727 temptmr\[0\] n706 ) nr2

xready_reg ( ready n706 clockt n701 ) qdffrbs
xflagtmr_reg ( flagtmr n729 clockt n701 ) qdffrbn
xg729 ( n729 n706 n714 ) or2b1s

ends sartesttimer4
