// $ Spice netlist generated by v2lvs
simulator lang=spectre insensitive=yes
//  v2011.1_15.11    thu feb 10 17:20:50 pst 2011
//	 global 0 gnd vcc
//  aliasGnd ( gnd 0 ) vsource type=dc dc=0
include "/Cad/DesignK/FaradayUMC180/DigitalCore/BackEnd/lvs/fsa0a_c_generic_core.scs"

subckt sarnormverilog ( clock reset compare ready clocktck clockcmp resetp resetn
+ saroutg sarout\[7\] sarout\[6\] sarout\[5\] sarout\[4\] sarout\[3\] sarout\[2\]
+ sarout\[1\] sarout\[0\] dataout\[7\] dataout\[6\] dataout\[5\] dataout\[4\] dataout\[3\]
+ dataout\[2\] dataout\[1\] dataout\[0\] )
xg298 ( saroutg resetn ) buf4
xg299 ( resetp reset ) buf4
xg300 ( n39 statep\[0\] statep\[1\] ) nr2
xg455 ( sarout\[0\] n28 resetn ) nd2
xg456 ( n28 sar\[0\] tempsar\[0\] ) or2
xg459 ( sarout\[1\] n27 resetn ) nd2
xg460 ( n27 sar\[1\] tempsar\[1\] ) or2
xg461 ( n24 n17 sar\[1\] ) an2
xsar_reg\[1\] ( sar\[1\] n23 clock resetn ) qdffrbn
xg463 ( sarout\[2\] n26 resetn ) nd2
xg464 ( n26 sar\[2\] tempsar\[2\] ) or2
xg465 ( n23 n17 sar\[2\] ) an2
xsar_reg\[2\] ( sar\[2\] n22 clock resetn ) qdffrbn
xg467 ( sarout\[3\] n60 resetn ) nd2
xg468 ( n22 n17 sar\[3\] ) an2
xg469 ( n60 sar\[3\] tempsar\[3\] ) or2
xsar_reg\[3\] ( sar\[3\] n21 clock resetn ) qdffrbn
xg471 ( sarout\[4\] n59 resetn ) nd2
xg472 ( n21 n17 sar\[4\] ) an2
xg473 ( n59 sar\[4\] tempsar\[4\] ) or2
xsar_reg\[4\] ( sar\[4\] n20 clock resetn ) qdffrbn
xg475 ( sarout\[5\] n58 resetn ) nd2
xg476 ( n58 sar\[5\] tempsar\[5\] ) or2
xg477 ( n20 n17 sar\[5\] ) an2
xsar_reg\[5\] ( sar\[5\] n19 clock resetn ) qdffrbn
xg479 ( sarout\[6\] n57 resetn ) nd2p
xg480 ( n19 n17 sar\[6\] ) an2
xg481 ( n57 sar\[6\] tempsar\[6\] ) or2
xsar_reg\[6\] ( sar\[6\] n18 clock resetn ) qdffrbn
xg483 ( sarout\[7\] n56 resetn ) nd2t
xg484 ( n18 n17 sar\[7\] ) an2
xg485 ( n56 sar\[7\] tempsar\[7\] ) or2
xg486 ( clocktck n39 reset clock ) an3b2s
xg487 ( clockcmp n3 reset clock ) an3b2s
xsar_reg\[7\] ( sar\[7\] n39 clock resetn ) qdffrbn
xg489 ( n17 n50 ) inv1s
xg490 ( n50 n49 statep\[0\] ) nd2
xg492 ( resetn reset ) inv1s
xg663 ( n16 sar\[1\] n63 n50 sar\[5\] sar\[6\] n15 ) nr6
xtempsar_reg\[0\] ( tempsar\[0\] n14 clock resetn ) qdffrbn
xtempsar_reg\[1\] ( tempsar\[1\] n13 clock resetn ) qdffrbn
xtempsar_reg\[2\] ( tempsar\[2\] n12 clock resetn ) qdffrbn
xtempsar_reg\[3\] ( tempsar\[3\] n11 clock resetn ) qdffrbn
xtempsar_reg\[4\] ( tempsar\[4\] n10 clock resetn ) qdffrbn
xtempsar_reg\[5\] ( tempsar\[5\] n9 clock resetn ) qdffrbn
xtempsar_reg\[6\] ( tempsar\[6\] n8 clock resetn ) qdffrbn
xtempsar_reg\[7\] ( tempsar\[7\] n7 clock resetn ) qdffrbn
xdataout_reg\[5\] ( dataout\[5\] tempsar\[5\] dataout\[5\] clock n5 resetn ) qdfzrbn
xdataout_reg\[6\] ( dataout\[6\] tempsar\[6\] dataout\[6\] clock n5 resetn ) qdfzrbn
xdataout_reg\[7\] ( dataout\[7\] tempsar\[7\] dataout\[7\] clock n5 resetn ) qdfzrbn
xdataout_reg\[0\] ( dataout\[0\] tempsar\[0\] dataout\[0\] clock n5 resetn ) qdfzrbn
xdataout_reg\[1\] ( dataout\[1\] tempsar\[1\] dataout\[1\] clock n5 resetn ) qdfzrbn
xdataout_reg\[2\] ( dataout\[2\] tempsar\[2\] dataout\[2\] clock n5 resetn ) qdfzrbn
xdataout_reg\[3\] ( dataout\[3\] tempsar\[3\] dataout\[3\] clock n5 resetn ) qdfzrbn
xdataout_reg\[4\] ( dataout\[4\] tempsar\[4\] dataout\[4\] clock n5 resetn ) qdfzrbn
xg680 ( n15 resetn n2 n1 ) nd3
xg681 ( n14 tempsar\[0\] n3 n28 n6 ) ao22
xg682 ( n13 tempsar\[1\] n3 n27 n6 ) ao22
xg683 ( n12 tempsar\[2\] n3 n26 n6 ) ao22
xg684 ( n11 tempsar\[3\] n3 n60 n6 ) ao22
xg685 ( n10 tempsar\[4\] n3 n59 n6 ) ao22
xg686 ( n9 tempsar\[5\] n3 n58 n6 ) ao22
xg687 ( n8 tempsar\[6\] n3 n57 n6 ) ao22
xg688 ( n7 tempsar\[7\] n3 n56 n6 ) ao22
xready_reg ( ready n4 clock resetn ) qdffrbn
xstatep_reg\[0\] ( statep\[0\] n49 clock resetn ) qdffrbn
xg691 ( n6 compare n39 ) an2b1s
xg692 ( n4 n5 ) inv1s
xg693 ( n5 n49 statep\[0\] ) or2b1s
xg695 ( n2 sar\[2\] sar\[4\] ) nr2
xg696 ( n1 sar\[7\] sar\[3\] ) nr2
xg714 ( n3 n39 ) inv1s
xsar_reg\[0\] ( sar\[0\] n63 n24 clock resetn ) dffrbn
xstatep_reg\[1\] ( statep\[1\] n49 n16 clock resetn ) dffrbn
ends sarnormverilog
