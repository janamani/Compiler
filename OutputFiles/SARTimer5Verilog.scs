// $ Spice netlist generated by v2lvs
simulator lang=spectre insensitive=yes
//  v2011.1_15.11    thu feb 10 17:20:50 pst 2011
//  global 0 gnd vcc
//  aliasGnd ( gnd 0 ) vsource type=dc dc=0
include "/Cad/DesignK/FaradayUMC180/DigitalCore/BackEnd/lvs/fsa0a_c_generic_core.scs"

subckt sartimer5verilog ( statep\[1\] statep\[0\] sarout\[7\] sarout\[6\] sarout\[5\]
+ sarout\[4\] sarout\[3\] sarout\[2\] sarout\[1\] sarout\[0\] clockt reset inc dcr
+ ready resetp resetn saroutis saroutds saroutig saroutdg saroutcg clockdcr clockinc
+ clocktck dataout\[7\] dataout\[6\] dataout\[5\] dataout\[4\] dataout\[3\] dataout\[2\]
+ dataout\[1\] dataout\[0\] timerout\[4\] timerout\[3\] timerout\[2\] timerout\[1\]
+ timerout\[0\] sarouti\[7\] sarouti\[6\] sarouti\[5\] sarouti\[4\] sarouti\[3\]
+ sarouti\[2\] sarouti\[1\] sarouti\[0\] saroutd\[7\] saroutd\[6\] saroutd\[5\]
+ saroutd\[4\] saroutd\[3\] saroutd\[2\] saroutd\[1\] saroutd\[0\] saroutc\[7\]
+ saroutc\[6\] saroutc\[5\] saroutc\[4\] saroutc\[3\] saroutc\[2\] saroutc\[1\]
+ saroutc\[0\] )
xg200 ( clocktck clockdcr ) buf4
xg201 ( clockinc clockdcr ) buf4
xg202 ( saroutcg resetn ) buf4
xg203 ( saroutdg resetn ) buf4
xg204 ( saroutig resetn ) buf4
xg205 ( saroutds saroutis ) buf4
xg206 ( saroutis resetp ) buf4
xg431 ( n105 n6 ) inv1s
xg426 ( n104 n119 ) inv1s
xg444 ( sarouti\[7\] n162 ) buf4
xg443 ( saroutd\[7\] n170 ) buf4
xg442 ( resetp reset ) buf1ck
xg509 ( n83 statep\[0\] ) inv3
xready_reg ( ready n276 clockt resetn ) qdffrbs
xg495 ( n81 n80 temptmr\[4\] ) nd2
xg496 ( clockdcr clockt resetp n78 ) nr3p
xg497 ( n117 n80 ) inv1s
xg510 ( n80 temptmr\[0\] temptmr\[2\] temptmr\[3\] temptmr\[1\] ) an4
xsaroutc_reg\[0\] ( saroutc\[0\] 1000 n7 clockt resetn ) dffsbn
xsaroutc_reg\[1\] ( saroutc\[1\] 1001 n6 clockt resetn ) dffsbn
xsaroutc_reg\[7\] ( saroutc\[7\] 1002 n266 clockt resetn ) dffsbt
xsaroutc_reg\[6\] ( saroutc\[6\] 1003 n115 clockt resetn ) dffsbn
xsaroutc_reg\[5\] ( saroutc\[5\] 1004 n118 clockt resetn ) dffsbn
xsaroutc_reg\[4\] ( saroutc\[4\] 1005 n119 clockt resetn ) dffsbn
xsaroutc_reg\[3\] ( saroutc\[3\] 1006 n120 clockt resetn ) dffsbn
xsaroutc_reg\[2\] ( saroutc\[2\] 1007 n121 clockt resetn ) dffsbn
xg512 ( n78 n330 n333 ) nr2
xg513 ( n120 sarout\[3\] ) inv1
xg514 ( n119 sarout\[4\] ) inv1s
xg516 ( resetn resetp ) inv2
xg518 ( n118 sarout\[5\] ) inv1s
xg519 ( n121 sarout\[2\] ) inv1s
xg521 ( n115 sarout\[6\] ) inv1s
xsaroutd_reg\[7\] ( n170 1008 n417 clockt resetn ) dffsbn
xsaroutd_reg\[6\] ( saroutd\[6\] 1009 n75 clockt resetn ) dffsbt
xg1361 ( n75 n399 n324 n18 ) nd3
xsaroutd_reg\[5\] ( saroutd\[5\] 1010 n73 clockt resetn ) dffsbp
xg1364 ( n73 n72 n324 ) nd2p
xg1366 ( n72 n244 n190 n193 saroutd\[5\] ) aoi22s
xsaroutd_reg\[4\] ( saroutd\[4\] 1011 n70 clockt resetn ) dffsbn
xg1369 ( n70 n279 n324 ) nd2
xsaroutd_reg\[3\] ( saroutd\[3\] 1012 n66 clockt resetn ) dffsbn
xg1375 ( n66 n64 n324 ) nd2
xg1377 ( n64 n190 n57 n193 saroutd\[3\] ) aoi22s
xsaroutd_reg\[2\] ( saroutd\[2\] 1013 n61 clockt resetn ) dffsbn
xtemptmr_reg\[3\] ( temptmr\[3\] n62 clockt resetn ) qdffrbn
xsarouti_reg\[1\] ( sarouti\[1\] 1014 n56 clockt resetn ) dffsbn
xsarouti_reg\[2\] ( sarouti\[2\] 1015 n55 clockt resetn ) dffsbn
xsarouti_reg\[3\] ( sarouti\[3\] 1016 n54 clockt resetn ) dffsbn
xsarouti_reg\[4\] ( sarouti\[4\] 1017 n53 clockt resetn ) dffsbn
xsarouti_reg\[5\] ( sarouti\[5\] 1018 n52 clockt resetn ) dffsbp
xsarouti_reg\[6\] ( sarouti\[6\] 1019 n51 clockt resetn ) dffsbt
xsarouti_reg\[7\] ( n162 1020 n50 clockt resetn ) dffsbn
xsarouti_reg\[0\] ( sarouti\[0\] 1021 n59 clockt resetn ) dffsbn
xg1389 ( n62 n58 n276 ) nr2
xg1390 ( n61 n49 n324 ) nd2
xtemptmr_reg\[2\] ( temptmr\[2\] n48 clockt resetn ) qdffrbp
xg1393 ( n59 n47 n45 ) nd2
xg1394 ( n58 temptmr\[3\] n0 ) xnr2hs
xg1395 ( n57 n36 sarout\[3\] n36 sarout\[3\] ) moai1s
xg1396 ( n56 n44 n105 n183 sarouti\[1\] ) moai1
xg1397 ( n55 n44 sarout\[2\] n183 sarouti\[2\] ) moai1
xg1398 ( n54 n44 sarout\[3\] n183 sarouti\[3\] ) moai1
xg1399 ( n53 n44 n104 n183 sarouti\[4\] ) moai1
xg1400 ( n52 n44 sarout\[5\] n183 sarouti\[5\] ) moai1
xg1401 ( n51 n44 sarout\[6\] n183 sarouti\[6\] ) moai1
xg1402 ( n50 n44 sarout\[7\] n183 n162 ) moai1
xg1403 ( n49 n190 n416 n183 saroutd\[2\] ) aoi22s
xsaroutd_reg\[1\] ( saroutd\[1\] 1022 n42 clockt resetn ) dffsbn
xg1405 ( n48 n39 n276 ) nr2
xg1406 ( n47 n43 n7 ) nd2s
xg1408 ( n45 n371 n190 n193 sarouti\[0\] ) aoi22s
xsaroutd_reg\[0\] ( saroutd\[0\] 1023 n41 clockt resetn ) dffsbn
xg1410 ( n44 n43 ) inv3
xg1411 ( n43 n371 n193 ) nr2p
xg1412 ( n42 n37 n324 ) nd2
xtemptmr_reg\[1\] ( temptmr\[1\] n35 clockt resetn ) qdffrbn
xg1414 ( n41 n24 n324 ) nd2
xg1416 ( n39 temptmr\[2\] n16 ) xor2hs
xg1418 ( n37 n190 n29 n183 saroutd\[1\] ) aoi22s
xtemptmr_reg\[4\] ( temptmr\[4\] n32 clockt resetn ) qdffrbn
xg1420 ( n36 sarout\[2\] n15 ) nr2f
xg1422 ( n35 n1 n276 ) nr2
xg1424 ( n33 n28 sarout\[3\] sarout\[2\] ) nd3
xdataout_reg\[0\] ( dataout\[0\] 1024 dataout\[0\] sarout\[0\] clockt n335 resetn
+ ) dfzsbn
xdataout_reg\[2\] ( dataout\[2\] sarout\[2\] dataout\[2\] clockt n290 resetn ) qdfzrbn
xdataout_reg\[3\] ( dataout\[3\] sarout\[3\] dataout\[3\] clockt n236 resetn ) qdfzrbn
xdataout_reg\[4\] ( dataout\[4\] sarout\[4\] dataout\[4\] clockt n236 resetn ) qdfzrbn
xdataout_reg\[1\] ( dataout\[1\] sarout\[1\] dataout\[1\] clockt n236 resetn ) qdfzrbn
xdataout_reg\[6\] ( dataout\[6\] sarout\[6\] dataout\[6\] clockt n290 resetn ) qdfzrbn
xdataout_reg\[5\] ( dataout\[5\] sarout\[5\] dataout\[5\] clockt n236 resetn ) qdfzrbn
xdataout_reg\[7\] ( dataout\[7\] sarout\[7\] dataout\[7\] clockt n290 resetn ) qdfzrbn
xtimerout_reg\[0\] ( timerout\[0\] n22 clockt resetn ) qdffrbn
xtimerout_reg\[1\] ( timerout\[1\] n23 clockt resetn ) qdffrbn
xtimerout_reg\[2\] ( timerout\[2\] n21 clockt resetn ) qdffrbn
xtimerout_reg\[3\] ( timerout\[3\] n20 clockt resetn ) qdffrbn
xtimerout_reg\[4\] ( timerout\[4\] n19 clockt resetn ) qdffrbn
xg1438 ( n32 n25 n276 ) nr2
xg1439 ( n31 n27 n12 n11 ) nd3
xg1441 ( n29 n28 sarout\[0\] sarout\[1\] ) ha1
xtemptmr_reg\[0\] ( temptmr\[0\] n2 clockt resetn ) qdffrbp
xg1444 ( n27 sarout\[7\] sarout\[6\] sarout\[1\] ) nr3
xg1446 ( n25 temptmr\[4\] n117 ) xor2hs
xg1447 ( n24 n193 saroutd\[0\] n190 sarout\[0\] ) aoi22s
xg1448 ( n23 n276 timerout\[1\] temptmr\[1\] ) mux2
xg1449 ( n22 n276 timerout\[0\] temptmr\[0\] ) mux2
xg1450 ( n21 n276 timerout\[2\] temptmr\[2\] ) mux2
xg1451 ( n20 n276 timerout\[3\] temptmr\[3\] ) mux2
xg1452 ( n19 n276 timerout\[4\] temptmr\[4\] ) mux2
xg1454 ( n18 n183 saroutd\[6\] ) nd2s
xg1455 ( n17 n183 n170 ) nd2s
xg1456 ( n16 temptmr\[1\] temptmr\[0\] ) nd2
xg1457 ( n15 n7 n6 ) nd2t
xg1458 ( n14 sarout\[4\] sarout\[7\] ) an2s
xg1460 ( n12 sarout\[4\] sarout\[5\] ) nr2
xg1461 ( n11 sarout\[3\] sarout\[2\] ) nr2
xg1467 ( n7 sarout\[0\] ) inv2
xg1469 ( n6 sarout\[1\] ) inv2
xg2 ( n3 sarout\[6\] n226 ) xor2
xg1480 ( n2 n276 temptmr\[0\] ) or2b1s
xg1481 ( n1 temptmr\[1\] temptmr\[0\] ) xnr2hs
xg1482 ( n0 temptmr\[2\] n16 ) an2b1s
xfopt1484 ( n183 n193 ) buf6
xfopt1488 ( n190 n193 ) inv3
xg1494 ( n206 n276 n370 ) or2s
xg1507 ( n219 statep\[1\] ) inv4
xg1512 ( n226 n225 n36 ) nd2
xg1513 ( n225 sarout\[3\] sarout\[5\] sarout\[4\] ) nr3
xg1514 ( n229 sarout\[4\] n277 ) nr2p
xfopt1521 ( n236 n334 ) inv4ck
xg1526 ( n244 n229 sarout\[5\] ) xnr2hs
xg1531 ( n250 n219 dcr inc ) oai12h
xg80 ( n266 sarout\[7\] ) inv1s
xg25 ( n276 n81 n302 ) nd2t
xg69 ( n279 n190 n278 n193 saroutd\[4\] ) aoi22s
xg70 ( n278 n277 sarout\[4\] ) xor2hs
xg71 ( n277 n36 n120 ) nd2p
xg132 ( n290 n335 ) inv2ck
xg121 ( n297 reset ) inv1s
xg113 ( n302 n325 n366 n297 ) nd3
xg108 ( n193 n321 ) inv6
xg110 ( n321 n336 ) buf2
xg1542 ( n319 statep\[1\] statep\[0\] ) nd2p
xg106 ( n324 n193 n31 ) or2p
xg107 ( n325 n336 n250 ) nd2t
xg1545 ( n330 n319 ) inv1s
xg38 ( n333 n332 n325 n297 ) aoi12h
xg41 ( n332 n331 ) buf4ck
xg42 ( n331 n219 n83 ) nd2f
xg39 ( n334 n332 ) inv3
xg40 ( n335 n332 ) inv4
xg37 ( n336 n331 n319 ) nd2t
xflagtmr_reg ( 1025 n366 n206 clockt resetn ) dffrbn
xg1567 ( n370 n325 reset ) an2b1s
xg1568 ( n371 n14 sarout\[5\] sarout\[6\] n33 ) an4b1
xg1579 ( n399 n183 n3 ) or2b1s
xg1588 ( n416 n15 sarout\[2\] ) xor2
xg1589 ( n417 n419 n17 ) nd2
xg1590 ( n419 n418 n190 ) nd2
xg1591 ( n418 sarout\[7\] sarout\[6\] n226 ) oai12s
ends sartimer5verilog
