// $ Spice netlist generated by v2lvs
simulator lang=spectre insensitive=yes
//  v2011.1_15.11    thu feb 10 17:20:50 pst 2011
global 0 gnd vcc
aliasGnd ( gnd 0 ) vsource type=dc dc=0
include "/Cad/DesignK/FaradayUMC180/DigitalCore/BackEnd/lvs/fsa0a_c_generic_core.spi"

subckt sartimerverilog_timer4 ( reset clockt statep\[1\] statep\[0\] inc dcr ready
+ timerout\[3\] timerout\[2\] timerout\[1\] timerout\[0\] flagconv )
xtimerout_reg\[0\] ( timerout\[0\] n28 clockt n31 ) qdffrbs
xtimerout_reg\[2\] ( timerout\[2\] n30 clockt n31 ) qdffrbs
xtimerout_reg\[3\] ( timerout\[3\] n26 clockt n31 ) qdffrbs
xtimerout_reg\[1\] ( timerout\[1\] n24 clockt n31 ) qdffrbs
xflagtmr_reg ( flagtmr n42 clockt n31 ) qdffrbn
xtemptmr_reg\[2\] ( temptmr\[2\] n23 clockt n31 ) qdffrbn
xtemptmr_reg\[3\] ( temptmr\[3\] n18 clockt n31 ) qdffrbn
xtemptmr_reg\[1\] ( temptmr\[1\] n20 clockt n31 ) qdffrbp
xtemptmr_reg\[0\] ( temptmr\[0\] n21 clockt n31 ) qdffrbp
xg419 ( n30 n27 n1 n22 ) mxl2hs
xg417 ( n28 n27 n0 n2 ) mxl2hs
xg416 ( n26 n27 n3 n17 ) mxl2hs
xg418 ( n24 n27 n4 n19 ) mxl2hs
xg421 ( n23 n9 n22 temptmr\[2\] n27 ) muxb2
xready_reg ( ready n27 clockt n31 ) qdffrbs
xg423 ( n21 temptmr\[0\] n27 ) nr2
xg424 ( n20 temptmr\[0\] temptmr\[1\] n19 n27 ) muxb2
xg425 ( n18 n27 n11 n17 ) aoi12s
xg427 ( n27 n12 n15 ) nd2t
xg431 ( n15 flagtmr n14 ) or2
xg432 ( flagconv n14 ) inv1s
xg428 ( n12 n10 temptmr\[3\] ) nd2p
xg433 ( n14 n8 n7 ) nd2p
xg429 ( n11 n10 ) inv1s
xg430 ( n10 n22 n9 ) nr2p
xg434 ( n8 n5 n6 ) nd2
xg435 ( n7 reset statep\[0\] statep\[1\] ) aoi12s
xg438 ( n9 temptmr\[1\] temptmr\[0\] ) nd2
xg436 ( n6 inc dcr ) nr2
xg437 ( n5 statep\[0\] statep\[1\] ) nr2
xg444 ( n17 temptmr\[3\] ) inv1s
xg446 ( n4 timerout\[1\] ) inv1s
xg440 ( n3 timerout\[3\] ) inv1s
xg441 ( n22 temptmr\[2\] ) inv2
xg443 ( n19 temptmr\[1\] ) inv1s
xg447 ( n2 temptmr\[0\] ) inv1s
xg442 ( n1 timerout\[2\] ) inv1s
xg439 ( n31 reset ) inv1s
xg445 ( n0 timerout\[0\] ) inv1s
xg2 ( n42 n27 n14 ) or2b1s
ends sartimerverilog_timer4
