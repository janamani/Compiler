// $ Spice netlist generated by v2lvs
simulator lang=spectre insensitive=yes
//  v2011.1_15.11    thu feb 10 17:20:50 pst 2011
//  global 0 gnd vcc
//  aliasGnd ( gnd 0 ) vsource type=dc dc=0
include "/Cad/DesignK/FaradayUMC180/DigitalCore/BackEnd/lvs/fsa0a_c_generic_core.scs"

subckt sarfastverilog ( clock reset inc dcr compare dataout\[7\] dataout\[6\] dataout\[5\]
+ dataout\[4\] dataout\[3\] dataout\[2\] dataout\[1\] dataout\[0\] clockcmp statep\[1\]
+ statep\[0\] sarout\[7\] sarout\[6\] sarout\[5\] sarout\[4\] sarout\[3\] sarout\[2\]
+ sarout\[1\] sarout\[0\] )
xg2485 ( n112 n150 ) inv1s
xg2486 ( n135 n123 ) inv1s
xg2483 ( n123 statep\[0\] statep\[1\] ) or2
xg3022 ( sarout\[0\] reset n111 ) nr2
xg3023 ( n144 n111 ) inv1s
xg3024 ( n111 sar\[0\] tempsar\[0\] ) nr2
xsar_reg\[0\] ( sar\[0\] n110 clock n4 ) qdffrbs
xg3026 ( n110 n85 sar\[1\] n98 n86 n87 n101 ) ao222
xg3027 ( sarout\[1\] n143 n4 ) an2
xg3028 ( n143 sar\[1\] tempsar\[1\] ) or2
xsar_reg\[1\] ( sar\[1\] n109 clock n4 ) qdffrbs
xg3030 ( n109 n85 sar\[2\] n98 n77 n87 n100 ) ao222
xg3031 ( sarout\[2\] n142 n4 ) an2
xg3032 ( n142 sar\[2\] tempsar\[2\] ) or2
xsar_reg\[2\] ( sar\[2\] n108 clock n4 ) qdffrbs
xg3034 ( n108 n85 sar\[3\] n98 dataout\[2\] n87 n99 ) ao222
xg3035 ( sarout\[3\] n141 n4 ) an2
xg3036 ( n141 sar\[3\] tempsar\[3\] ) or2
xsar_reg\[3\] ( sar\[3\] n107 clock n4 ) qdffrbs
xg3038 ( n107 n106 n97 ) nd2
xg3039 ( sarout\[4\] n140 n4 ) an2
xg3040 ( n106 n85 sar\[4\] n87 n96 ) aoi22s
xg3041 ( n140 sar\[4\] tempsar\[4\] ) or2
xsar_reg\[4\] ( sar\[4\] n105 clock n4 ) qdffrbs
xg3043 ( n105 n85 sar\[5\] n94 dataout\[4\] n87 n92 ) ao222
xg3044 ( sarout\[5\] n139 n4 ) an2
xg3045 ( n139 sar\[5\] tempsar\[5\] ) or2
xsar_reg\[5\] ( sar\[5\] n104 clock n4 ) qdffrbs
xg3047 ( n104 n103 n93 ) nd2
xg3048 ( sarout\[6\] n138 n4 ) an2
xg3049 ( n103 n85 sar\[6\] n87 n88 ) aoi22s
xg3050 ( n138 sar\[6\] tempsar\[6\] ) or2
xsar_reg\[6\] ( sar\[6\] n102 clock n4 ) qdffrbs
xg3052 ( n102 n85 sar\[7\] n90 dataout\[6\] n87 n84 ) ao222
xg3053 ( sarout\[7\] n137 n4 ) an2
xg3054 ( n147 n101 ) inv1s
xg3055 ( n101 dataout\[0\] n150 ) nr2
xg3056 ( n137 sar\[7\] tempsar\[7\] ) or2
xg3057 ( n100 dataout\[1\] n119 ) nr2
xg3058 ( n150 n119 dataout\[1\] ) or2b1s
xsar_reg\[7\] ( sar\[7\] n95 clock n4 ) qdffrbs
xg3060 ( n99 dataout\[2\] n120 ) nr2
xg3061 ( n119 n120 dataout\[2\] ) or2b1s
xg3062 ( n98 n94 dataout\[4\] dataout\[3\] ) an3b2s
xg3063 ( n97 n94 n81 dataout\[3\] ) nd3
xg3064 ( n96 dataout\[3\] n121 ) nr2
xg3065 ( n120 n91 dataout\[3\] ) nd2
xg3066 ( n95 n134 n89 ) nr2
xg3067 ( n94 n90 dataout\[6\] dataout\[5\] ) an3b2s
xg3068 ( n93 n90 n82 dataout\[5\] ) nd3
xg3069 ( n92 dataout\[4\] n122 ) nr2
xg3070 ( n121 n91 ) inv1s
xg3071 ( n91 n81 n122 ) nr2
xg3072 ( n90 dataout\[7\] n146 n134 ) nr3
xg3073 ( n89 dataout\[7\] n145 n146 ) mux2
xg3074 ( n122 n118 dataout\[5\] ) nd2
xg3075 ( n88 dataout\[5\] n83 ) nr2
xg3076 ( n87 n145 n134 ) nr2
xg3077 ( clockcmp clock n135 reset ) nr3
xg3078 ( n86 dataout\[0\] dataout\[2\] dataout\[1\] ) an3b2s
xg3079 ( n85 n79 statep\[1\] ) an2
xg3080 ( n146 n80 checkid\[0\] ) nd2
xg3081 ( n145 checkid\[0\] n80 ) or2
xg3082 ( n134 statep\[1\] n79 ) or2
xg3083 ( n84 n82 dataout\[7\] ) an2
xg3084 ( n118 n83 ) inv1s
xg3085 ( n83 dataout\[6\] dataout\[7\] ) nd2s
xg3087 ( n149 dataout\[1\] dataout\[6\] ) nd2
xg3088 ( n82 dataout\[6\] ) inv1s
xg3089 ( n81 dataout\[4\] ) inv1s
xg3093 ( n4 reset ) inv1s
xg2 ( n77 dataout\[1\] dataout\[2\] ) an2b1s
xtempsar_reg\[1\] ( tempsar\[1\] n74 clock n4 ) qdffrbn
xtempsar_reg\[6\] ( tempsar\[6\] n73 clock n4 ) qdffrbn
xtempsar_reg\[3\] ( tempsar\[3\] n72 clock n4 ) qdffrbn
xtempsar_reg\[2\] ( tempsar\[2\] n75 clock n4 ) qdffrbn
xtempsar_reg\[4\] ( tempsar\[4\] n71 clock n4 ) qdffrbn
xtempsar_reg\[5\] ( tempsar\[5\] n76 clock n4 ) qdffrbn
xtempsar_reg\[7\] ( tempsar\[7\] n70 clock n4 ) qdffrbn
xstatep_reg\[0\] ( statep\[0\] n79 n69 clock n4 ) dffsbn
xg3624 ( n76 n68 n26 ) nd2
xg3625 ( n75 n57 n64 n27 ) nd3
xg3626 ( n74 n67 n8 n143 ) ao12
xg3627 ( n73 n8 n138 n60 tempsar\[6\] n36 n161 ) ao222
xg3628 ( n72 n8 n141 n62 tempsar\[3\] n19 n55 ) ao222
xg3629 ( n71 n8 n140 n62 tempsar\[4\] n19 n54 ) ao222
xg3630 ( n70 n65 n50 n25 ) nd3
xg3631 ( n69 n4 n61 n56 ) oai12s
xg3632 ( n68 n53 n40 n62 tempsar\[5\] ) aoi112s
xg3633 ( n67 n20 n147 n62 tempsar\[1\] ) moai1s
xg3634 ( n66 n59 n160 n8 n144 ) moai1s
xg3635 ( n65 tempsar\[7\] n58 n0 ) oai12s
xg3636 ( n64 n63 n20 n43 n119 ) oa13s
xg3637 ( n63 n58 tempsar\[2\] ) nd2
xg3638 ( n62 n58 n7 n42 ) ao12
xg3639 ( n61 n52 n134 n146 n42 ) aoi112s
xg3640 ( n60 n58 n7 n118 ) ao12
xg3641 ( n59 n58 n7 n112 dataout\[0\] ) aoi13hs
xcheckid_reg\[0\] ( checkid\[0\] n49 clock n4 ) qdffrbn
xstatep_reg\[1\] ( statep\[1\] n3 n51 clock n4 ) dffsbn
xg3645 ( n58 n45 n46 ) nd2
xg3646 ( n57 n48 n43 dataout\[2\] ) nd3
xg3647 ( n56 n21 n11 n3 n31 ) oai112s
xg3648 ( n55 n120 n159 n43 n38 ) moai1s
xg3649 ( n54 n122 n44 n121 n15 ) oai22s
xg3650 ( n53 n35 n14 n33 dataout\[4\] ) aoi112s
xg3651 ( n52 n145 n146 n30 ) oa12
xg3652 ( n51 reset n123 n11 ) ao12
xg3653 ( n50 n19 dataout\[7\] n39 n28 ) oai112s
xg3654 ( n49 n18 checkid\[0\] n6 dcr ) ao22
xg3655 ( n48 n120 n37 n24 n149 ) oai22s
xg3656 ( n47 n18 checkid\[1\] n6 inc ) ao22
xg3657 ( n46 n3 checkid\[0\] checkid\[1\] n30 ) oai112s
xg3658 ( n45 n6 n17 n7 n80 ) aoi112s
xg3659 ( n44 n29 n33 ) or2
xg3660 ( n43 n1 n39 ) nr2
xg3661 ( n42 n29 n32 ) nr2
xg3663 ( n40 dataout\[0\] n122 n20 ) nr3
xg3664 ( n39 n29 dataout\[3\] ) or2b1s
xg3665 ( n38 n28 n121 ) an2b1s
xg3666 ( n37 n19 n149 ) nd2s
xg3667 ( n36 n35 ) inv1s
xg3668 ( n35 n19 n118 ) nd2s
xg3670 ( n33 n32 ) inv1s
xg3671 ( n32 n28 dataout\[7\] dataout\[3\] ) or3b2
xg3672 ( n31 n23 n13 sar\[0\] sar\[7\] ) an4b1s
xg3673 ( n30 n22 n10 n1 dataout\[0\] ) an4b1s
xg3674 ( n29 n15 dataout\[4\] ) nd2
xg3675 ( n28 dataout\[1\] dataout\[2\] dataout\[6\] ) nd3
xg3676 ( n27 n8 n142 ) nd2
xg3677 ( n26 n8 n139 ) nd2
xg3678 ( n25 n8 n137 ) nd2
xg3679 ( n24 n7 tempsar\[2\] ) nd2s
xg3681 ( n23 n12 sar\[1\] sar\[2\] ) an3b2s
xg3682 ( n22 n9 dataout\[3\] dataout\[6\] ) an3b2s
xg3683 ( n21 dcr inc n123 ) or3
xg3684 ( n19 n20 ) inv1s
xg3685 ( n20 n7 statep\[0\] checkid\[1\] ) nd3
xg3686 ( n18 n3 statep\[0\] n3 statep\[0\] ) moai1s
xg3687 ( n17 compare n3 ) nr2
xg3689 ( n15 n14 ) inv1s
xg3690 ( n14 dataout\[5\] dataout\[0\] ) nd2s
xg3691 ( n13 sar\[6\] sar\[5\] ) nr2
xg3692 ( n12 sar\[4\] sar\[3\] ) nr2
xg3693 ( n11 statep\[0\] statep\[1\] ) nd2
xg3694 ( n10 dataout\[4\] dataout\[2\] ) nr2
xg3695 ( n9 dataout\[1\] dataout\[5\] ) nr2
xg3696 ( n8 statep\[1\] compare ) an2
xg3698 ( n7 checkid\[0\] statep\[1\] ) nr2
xg3699 ( n6 statep\[1\] statep\[0\] ) nr2
xg3723 ( n1 dataout\[7\] ) inv1s
xg3094 ( n0 n7 n1 ) an2b1s
xg3725 ( n159 n29 ) inv1s
xcheckid_reg\[1\] ( checkid\[1\] n80 n47 clock n4 ) dffrbn
xtempsar_reg\[0\] ( tempsar\[0\] n160 n66 clock n4 ) dffrbn
xg3730 ( n161 n39 dataout\[2\] dataout\[1\] ) or3b2
ends sarfastverilog
