// $ Spice netlist generated by v2lvs
simulator lang=spectre insensitive=yes
//  v2011.1_15.11    thu feb 10 17:20:50 pst 2011
global 0 gnd vcc
aliasGnd ( gnd 0 ) vsource type=dc dc=0
include "/Cad/DesignK/FaradayUMC180/DigitalCore/BackEnd/lvs/fsa0a_c_generic_core.spi"

subckt sartimerverilog_timer8 ( reset clockt statep\[1\] statep\[0\] inc dcr ready
+ timerout\[7\] timerout\[6\] timerout\[5\] timerout\[4\] timerout\[3\] timerout\[2\]
+ timerout\[1\] timerout\[0\] flagconv )
xtimerout_reg\[7\] ( timerout\[7\] n53 clockt n63 ) qdffrbs
xtimerout_reg\[0\] ( timerout\[0\] n62 clockt n63 ) qdffrbs
xtimerout_reg\[1\] ( timerout\[1\] n61 clockt n63 ) qdffrbs
xtimerout_reg\[2\] ( timerout\[2\] n59 clockt n63 ) qdffrbs
xtimerout_reg\[3\] ( timerout\[3\] n58 clockt n63 ) qdffrbs
xtimerout_reg\[4\] ( timerout\[4\] n57 clockt n63 ) qdffrbs
xtimerout_reg\[5\] ( timerout\[5\] n56 clockt n63 ) qdffrbs
xtimerout_reg\[6\] ( timerout\[6\] n55 clockt n63 ) qdffrbs
xflagtmr_reg ( flagtmr n54 clockt n63 ) qdffrbs
xtemptmr_reg\[6\] ( temptmr\[6\] n43 clockt n63 ) qdffrbp
xtemptmr_reg\[7\] ( temptmr\[7\] n51 clockt n63 ) qdffrbn
xtemptmr_reg\[2\] ( temptmr\[2\] n79 clockt n63 ) qdffrbp
xtemptmr_reg\[5\] ( temptmr\[5\] n45 clockt n63 ) qdffrbp
xtemptmr_reg\[3\] ( temptmr\[3\] n52 clockt n63 ) qdffrbn
xtemptmr_reg\[0\] ( temptmr\[0\] n49 clockt n63 ) qdffrbp
xtemptmr_reg\[4\] ( temptmr\[4\] n78 clockt n63 ) qdffrbp
xtemptmr_reg\[1\] ( temptmr\[1\] n48 clockt n63 ) qdffrbp
xready_reg ( ready n60 clockt n63 ) qdffrbs
xg771 ( n62 n60 n0 n19 ) mxl2hs
xg772 ( n61 n60 n7 n18 ) mxl2hs
xg773 ( n59 n60 n6 n25 ) mxl2hs
xg774 ( n58 n60 n9 n5 ) mxl2hs
xg775 ( n57 n60 n1 n30 ) mxl2hs
xg776 ( n56 n60 n8 n38 ) mxl2hs
xg777 ( n55 n60 n10 n42 ) mxl2hs
xg781 ( n54 n46 n29 ) nd2
xg770 ( n53 n60 n3 n4 ) mxl2hs
xg751 ( n52 n34 n60 ) nr2
xg761 ( n51 n41 n60 ) nr2
xg782 ( n49 temptmr\[0\] n60 ) nr2
xg783 ( n48 n20 n60 ) nr2
xg750 ( n45 n40 n60 ) nr2
xg746 ( n43 n39 temptmr\[6\] n42 n60 ) muxb2
xg785 ( n46 n60 ) inv2
xg786 ( n60 n28 n36 ) nd2f
xg768 ( n41 temptmr\[7\] n32 n17 ) aoi12s
xg769 ( n40 temptmr\[5\] n37 ) xor2hs
xg780 ( n39 n38 n37 ) nr2
xg789 ( n36 flagconv n2 ) nd2p
xg762 ( n34 temptmr\[3\] n24 ) xnr2hs
xg788 ( n32 n37 ) inv1s
xg794 ( n29 flagconv ) inv1s
xg793 ( n28 n22 n27 ) nd2t
xg792 ( n37 n27 temptmr\[4\] ) nd2p
xg795 ( flagconv n21 n15 ) nr2t
xg799 ( n27 n14 n12 ) nr2f
xg790 ( n24 n25 n23 ) nr2
xg796 ( n22 n11 n16 ) nr2p
xg798 ( n21 n13 n63 ) nd2
xg800 ( n20 n19 temptmr\[1\] n18 temptmr\[0\] ) aoi22s
xg803 ( n17 n16 ) inv1s
xg797 ( n15 inc statep\[1\] dcr statep\[0\] ) nr4
xg806 ( n14 temptmr\[0\] temptmr\[2\] ) nd2p
xg807 ( n13 statep\[0\] statep\[1\] ) nd2
xg805 ( n12 temptmr\[1\] temptmr\[3\] ) nd2p
xg801 ( n11 temptmr\[4\] temptmr\[7\] ) nd2p
xg802 ( n23 temptmr\[1\] temptmr\[0\] ) nd2
xg804 ( n16 temptmr\[5\] temptmr\[6\] ) nd2
xg815 ( n42 temptmr\[6\] ) inv1s
xg812 ( n10 timerout\[6\] ) inv1s
xg811 ( n9 timerout\[3\] ) inv1s
xg809 ( n25 temptmr\[2\] ) inv1s
xg820 ( n8 timerout\[5\] ) inv1s
xg819 ( n30 temptmr\[4\] ) inv1s
xg816 ( n63 reset ) inv1s
xg824 ( n7 timerout\[1\] ) inv1s
xg817 ( n6 timerout\[2\] ) inv1s
xg818 ( n19 temptmr\[0\] ) inv1s
xg823 ( n5 temptmr\[3\] ) inv1s
xg825 ( n4 temptmr\[7\] ) inv1s
xg814 ( n18 temptmr\[1\] ) inv1s
xg808 ( n3 timerout\[7\] ) inv1s
xg821 ( n2 flagtmr ) inv1s
xg810 ( n1 timerout\[4\] ) inv1s
xg822 ( n0 timerout\[0\] ) inv1s
xg813 ( n38 temptmr\[5\] ) inv1s
xg2 ( n78 n27 temptmr\[4\] n30 n60 ) muxb2
xg844 ( n79 n23 n25 temptmr\[2\] n60 ) muxb2
ends sartimerverilog_timer8
