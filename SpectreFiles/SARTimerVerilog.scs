// $ Spice netlist generated by v2lvs
simulator lang=spectre insensitive=yes
//  v2011.1_15.11    thu feb 10 17:20:50 pst 2011
//  global 0 gnd vcc
//  aliasGnd ( gnd 0 ) vsource type=dc dc=0
include "/Cad/DesignK/FaradayUMC180/DigitalCore/BackEnd/lvs/fsa0a_c_generic_core.scs"

subckt sartimerverilog ( statep\[1\] statep\[0\] sarout\[7\] sarout\[6\] sarout\[5\]
+ sarout\[4\] sarout\[3\] sarout\[2\] sarout\[1\] sarout\[0\] clockt reset inc dcr
+ ready resetp resetn saroutis saroutds saroutig saroutdg saroutcg clockdcr clockinc
+ clocktck dataout\[7\] dataout\[6\] dataout\[5\] dataout\[4\] dataout\[3\] dataout\[2\]
+ dataout\[1\] dataout\[0\] timerout\[7\] timerout\[6\] timerout\[5\] timerout\[4\]
+ timerout\[3\] timerout\[2\] timerout\[1\] timerout\[0\] sarouti\[7\] sarouti\[6\]
+ sarouti\[5\] sarouti\[4\] sarouti\[3\] sarouti\[2\] sarouti\[1\] sarouti\[0\]
+ saroutd\[7\] saroutd\[6\] saroutd\[5\] saroutd\[4\] saroutd\[3\] saroutd\[2\]
+ saroutd\[1\] saroutd\[0\] saroutc\[7\] saroutc\[6\] saroutc\[5\] saroutc\[4\]
+ saroutc\[3\] saroutc\[2\] saroutc\[1\] saroutc\[0\] )
xg200 ( clocktck clockdcr ) buf4
xg201 ( clockinc clockdcr ) buf4
xg202 ( saroutcg resetn ) buf4
xg203 ( saroutdg resetn ) buf4
xg204 ( saroutig resetn ) buf4
xg205 ( saroutds saroutis ) buf4
xg452 ( saroutis resetp ) buf4
xg456 ( resetp reset ) buf1ck
xg449 ( sarouti\[7\] n189 ) buf6ck
xg457 ( saroutd\[7\] n197 ) buf6ck
xg517 ( n135 n108 ) inv1s
xg518 ( n108 statep\[1\] statep\[0\] ) nd2p
xg519 ( n107 statep\[1\] ) inv3
xready_reg ( ready n631 clockt resetn ) qdffrbs
xg523 ( clockdcr clockt resetp n98 ) nr3t
xsaroutc_reg\[0\] ( saroutc\[0\] 1000 n147 clockt resetn ) dffsbn
xsaroutc_reg\[1\] ( saroutc\[1\] 1001 n146 clockt resetn ) dffsbn
xsaroutc_reg\[7\] ( n397 1002 n134 clockt resetn ) dffsbn
xsaroutc_reg\[6\] ( saroutc\[6\] 1003 n139 clockt resetn ) dffsbn
xsaroutc_reg\[5\] ( saroutc\[5\] 1004 n142 clockt resetn ) dffsbn
xsaroutc_reg\[4\] ( saroutc\[4\] 1005 n538 clockt resetn ) dffsbn
xsaroutc_reg\[3\] ( saroutc\[3\] 1006 n17 clockt resetn ) dffsbn
xsaroutc_reg\[2\] ( saroutc\[2\] 1007 n145 clockt resetn ) dffsbn
xg538 ( n98 n135 n579 ) nr2
xg539 ( n134 sarout\[7\] ) inv1s
xg540 ( resetn resetp ) inv2
xg543 ( n147 n480 ) inv1s
xg545 ( n145 n622 ) inv1
xg546 ( n139 sarout\[6\] ) inv1s
xg547 ( n142 sarout\[5\] ) inv1s
xsaroutd_reg\[7\] ( n197 1008 n593 clockt resetn ) dffsbn
xsaroutd_reg\[6\] ( saroutd\[6\] 1009 n617 clockt resetn ) dffsbt
xg1533 ( n96 sarout\[7\] n264 ) xor2hs
xsaroutd_reg\[5\] ( saroutd\[5\] n646 n93 clockt resetn ) dffsbn
xg1537 ( n93 n600 n469 ) nd2p
xsaroutd_reg\[4\] ( saroutd\[4\] 1010 n90 clockt resetn ) dffsbn
xg1542 ( n90 n88 n469 ) nd2
xg1545 ( n88 n615 n597 n215 saroutd\[4\] ) aoi22s
xtemptmr_reg\[7\] ( temptmr\[7\] n639 clockt resetn ) qdffrbn
xsaroutd_reg\[3\] ( saroutd\[3\] 1011 n85 clockt resetn ) dffsbn
xg1550 ( n85 n601 n469 ) nd2
xg1553 ( n83 temptmr\[7\] n69 ) xnr2hs
xsaroutd_reg\[2\] ( saroutd\[2\] 1012 n78 clockt resetn ) dffsbn
xtemptmr_reg\[3\] ( temptmr\[3\] n660 clockt resetn ) qdffrbp
xg1560 ( n78 n560 n469 ) nd2
xtemptmr_reg\[2\] ( temptmr\[2\] n609 clockt resetn ) qdffrbp
xtemptmr_reg\[5\] ( temptmr\[5\] n585 clockt resetn ) qdffrbp
xsarouti_reg\[1\] ( sarouti\[1\] 1013 n654 clockt resetn ) dffsbn
xsarouti_reg\[2\] ( sarouti\[2\] 1014 n65 clockt resetn ) dffsbn
xsarouti_reg\[3\] ( sarouti\[3\] 1015 n64 clockt resetn ) dffsbn
xsarouti_reg\[4\] ( sarouti\[4\] 1016 n559 clockt resetn ) dffsbn
xsarouti_reg\[5\] ( 1017 n648 n653 clockt resetn ) dffsbn
xsarouti_reg\[6\] ( sarouti\[6\] 1018 n655 clockt resetn ) dffsbt
xsarouti_reg\[7\] ( n189 1019 n558 clockt resetn ) dffsbn
xsaroutd_reg\[1\] ( saroutd\[1\] 1020 n68 clockt resetn ) dffsbn
xsarouti_reg\[0\] ( sarouti\[0\] 1021 n479 clockt resetn ) dffsbn
xg1580 ( n69 n647 n495 ) nr2
xsaroutd_reg\[0\] ( saroutd\[0\] 1022 n58 clockt resetn ) dffsbn
xg1582 ( n68 n561 n469 ) nd2
xg1585 ( n65 n209 n622 n215 sarouti\[2\] ) moai1s
xg1586 ( n64 n215 sarout\[3\] n215 sarouti\[3\] ) moai1s
xtemptmr_reg\[4\] ( temptmr\[4\] n448 clockt resetn ) qdffrbp
xtemptmr_reg\[1\] ( temptmr\[1\] n445 clockt resetn ) qdffrbp
xg1593 ( n59 n597 n147 ) nd2
xg1594 ( n58 n553 n469 ) nd2
xdataout_reg\[0\] ( dataout\[0\] 1023 dataout\[0\] n480 clockt n580 resetn ) dfzsbn
xtimerout_reg\[0\] ( timerout\[0\] n641 clockt resetn ) qdffrbs
xtimerout_reg\[1\] ( timerout\[1\] n635 clockt resetn ) qdffrbs
xtimerout_reg\[2\] ( timerout\[2\] n644 clockt resetn ) qdffrbs
xtimerout_reg\[3\] ( timerout\[3\] n643 clockt resetn ) qdffrbs
xtimerout_reg\[4\] ( timerout\[4\] n633 clockt resetn ) qdffrbs
xtimerout_reg\[5\] ( timerout\[5\] n636 clockt resetn ) qdffrbs
xtimerout_reg\[6\] ( timerout\[6\] n642 clockt resetn ) qdffrbs
xtimerout_reg\[7\] ( timerout\[7\] n634 clockt resetn ) qdffrbs
xdataout_reg\[2\] ( dataout\[2\] n622 dataout\[2\] clockt n510 resetn ) qdfzrbn
xdataout_reg\[1\] ( dataout\[1\] n476 dataout\[1\] clockt n510 resetn ) qdfzrbn
xdataout_reg\[3\] ( dataout\[3\] sarout\[3\] dataout\[3\] clockt n510 resetn ) qdfzrbn
xdataout_reg\[4\] ( dataout\[4\] n539 dataout\[4\] clockt n510 resetn ) qdfzrbn
xdataout_reg\[5\] ( dataout\[5\] sarout\[5\] dataout\[5\] clockt n510 resetn ) qdfzrbn
xdataout_reg\[6\] ( dataout\[6\] sarout\[6\] dataout\[6\] clockt n510 resetn ) qdfzrbn
xdataout_reg\[7\] ( dataout\[7\] sarout\[7\] dataout\[7\] clockt n510 resetn ) qdfzrbn
xg1624 ( n44 n208 n39 ) nr2
xflagtmr_reg ( n148 n659 clockt resetn ) qdffrbn
xtemptmr_reg\[0\] ( temptmr\[0\] n447 clockt resetn ) qdffrbn
xg1631 ( n39 n1 sarout\[5\] sarout\[6\] ) nd3
xg1643 ( n28 n337 n476 n337 n476 ) moai1s
xg1646 ( n26 n209 n197 ) nd2s
xg1651 ( n3 n145 n146 ) nr2
xg1652 ( n22 sarout\[4\] sarout\[5\] ) nr2
xg1657 ( n17 sarout\[3\] ) inv2
xg2 ( n4 sarout\[6\] n393 ) xor2
xg1688 ( n1 n539 n17 ) an2b1s
xg1692 ( n208 n3 sarout\[7\] ) nd2
xfopt1699 ( n215 n597 ) inv4
xg1731 ( n264 n626 sarout\[6\] n539 ) nr3h
xg1753 ( n340 n622 n339 ) xor2hs
xg1754 ( n339 n623 ) buf1ck
xg24 ( n360 sarout\[5\] ) inv2
xg1765 ( n365 n363 n364 ) nr2p
xg21 ( n363 temptmr\[7\] temptmr\[5\] ) nd2p
xg1766 ( n364 temptmr\[4\] temptmr\[6\] ) nd2
xg1767 ( n370 n107 n474 ) nd2s
xg1769 ( n367 dcr ) inv2
xg28 ( n368 inc ) inv2
xg1781 ( n393 n614 n392 ) nd2p
xg1783 ( n392 n360 n539 ) an2b1s
xfopt1785 ( saroutc\[7\] n397 ) buf6ck
xg1793 ( n408 reset ) inv1s
xg1804 ( n425 n534 temptmr\[1\] temptmr\[2\] ) nd3
xg1808 ( n427 temptmr\[1\] n534 ) nd2
xg1809 ( n428 temptmr\[1\] n534 ) xnr2hs
xg1819 ( n436 temptmr\[3\] n425 ) xnr2hs
xg1826 ( n445 n428 n631 ) nr2
xg1827 ( n447 n637 n534 ) nd2
xg1829 ( n448 n640 n472 ) an2
xg1836 ( n454 statep\[0\] ) inv3
xg1840 ( n467 n583 ) inv2
xg1841 ( n469 n583 ) inv4
xg1842 ( n472 temptmr\[4\] n611 ) xor2hs
xg1845 ( n474 n368 n367 ) nd2
xg1846 ( n476 n146 ) inv1
xg4 ( n146 sarout\[1\] ) inv4
xg30 ( n479 n477 n59 n478 ) nd3
xg31 ( n477 n209 sarouti\[0\] ) nd2s
xg32 ( n478 n44 n597 ) nd2s
xg1847 ( n480 sarout\[0\] ) buf1ck
xg1849 ( n337 sarout\[0\] ) inv2
xg41 ( n484 reset n368 n367 ) aoi12s
xg60 ( n491 temptmr\[1\] temptmr\[0\] ) nd2p
xg55 ( n495 n547 temptmr\[5\] ) nd2p
xg46 ( n498 sarout\[6\] sarout\[7\] n476 ) nr3
xfopt1862 ( n510 n580 ) inv3ck
xfopt1875 ( n534 temptmr\[0\] ) buf1
xfopt1877 ( n538 n539 ) inv1s
xfopt1881 ( n539 sarout\[4\] ) buf2
xg1884 ( n547 temptmr\[4\] temptmr\[2\] temptmr\[3\] n491 ) an4b1
xg1889 ( n211 n597 ) inv4
xg1890 ( n553 n211 saroutd\[0\] n597 n480 ) aoi22s
xg1895 ( n558 n211 sarout\[7\] n211 n189 ) moai1s
xg1896 ( n559 n211 n539 n211 sarouti\[4\] ) moai1s
xg1897 ( n560 n597 n340 n209 saroutd\[2\] ) aoi22s
xg1898 ( n561 n597 n28 n209 saroutd\[1\] ) aoi22s
xg1907 ( n575 n637 n574 ) an2b1s
xg1908 ( n574 n495 temptmr\[6\] ) xor2hs
xg20 ( n579 n484 n578 ) nr2
xg1910 ( n578 n107 n454 ) nd2f
xg1911 ( n580 n578 ) inv3
xg1913 ( n583 n652 n605 ) nr2t
xg1915 ( n585 n640 n656 ) an2
xg1916 ( n586 sarout\[5\] ) buf1
xg1919 ( n591 n215 saroutd\[6\] ) nd2s
xg26 ( n593 n26 n467 n96 n209 ) oai112s
xg64 ( n600 n657 n211 n215 n646 ) moai1
xg73 ( n596 n578 n108 ) nd2p
xg63 ( n601 n628 n597 n215 saroutd\[3\] ) aoi22s
xg70 ( n209 n597 ) inv3
xg71 ( n597 n596 ) buf6
xg65 ( n605 n498 n596 ) nd2s
xg66 ( n607 n606 n370 ) nd2p
xg72 ( n606 n578 n108 ) nd2p
xg1921 ( n609 n640 n608 ) an2
xg1922 ( n608 temptmr\[2\] n427 ) xnr2hs
xg14 ( n611 n610 n491 ) nr2t
xg15 ( n610 temptmr\[2\] temptmr\[3\] ) nd2p
xg1923 ( n613 n539 n625 ) nr2
xg1925 ( n614 n625 ) inv2
xg29 ( n615 n539 n614 ) xnr2hs
xg1926 ( n617 n616 n469 n591 ) nd3p
xg1927 ( n616 n4 n597 ) nd2p
xg1929 ( n622 sarout\[2\] ) buf3
xg1930 ( n623 n337 n146 ) nd2t
xg1931 ( n625 n624 n17 ) nd2p
xg1932 ( n624 n622 n623 ) nr2f
xg1933 ( n626 n624 n17 n360 ) nd3
xg1934 ( n628 n627 sarout\[3\] n627 sarout\[3\] ) moai1s
xg1848_dup ( n627 n622 n623 ) nr2
xg1935 ( n629 n611 n365 ) nd2t
xg1936 ( n630 n607 n658 ) nd2t
xg1938 ( n631 n629 n630 ) nd2f
xg1939 ( n633 n631 timerout\[4\] temptmr\[4\] ) mux2
xg1940 ( n634 n631 timerout\[7\] temptmr\[7\] ) mux2
xg1941 ( n635 n631 timerout\[1\] temptmr\[1\] ) mux2
xg1942 ( n636 n631 timerout\[5\] temptmr\[5\] ) mux2
xfopt1943 ( n637 n631 ) inv2
xg1944 ( n639 n638 n83 ) nr2
xg11_dup ( n638 n629 n630 ) nd2t
xfopt1945 ( n640 n638 ) inv2ck
xg1946 ( n641 n638 timerout\[0\] n534 ) mux2
xg1947 ( n642 n638 timerout\[6\] temptmr\[6\] ) mux2
xg1948 ( n643 n638 timerout\[3\] temptmr\[3\] ) mux2
xg1949 ( n644 n638 timerout\[2\] temptmr\[2\] ) mux2
xtemptmr_reg\[6\] ( temptmr\[6\] n647 n575 clockt resetn ) dffrbn
xg13 ( sarouti\[5\] n648 ) inv3
xg1953 ( n652 n622 sarout\[3\] n22 ) or3b1s
xg1954 ( n653 n211 n142 sarouti\[5\] ) mux2
xg1955 ( n654 n215 n146 sarouti\[1\] ) mux2
xg1956 ( n655 n211 n139 sarouti\[6\] ) mux2
xg1957 ( n656 temptmr\[5\] n547 ) xor2
xg1958 ( n657 n613 n586 ) xnr2hs
xg1959 ( n658 n408 n148 ) an2b1
xg1960 ( n659 n631 n607 n408 ) ao12
xg1961 ( n660 n436 n630 ) an2
ends sartimerverilog
