// $ Spice netlist generated by v2lvs
simulator lang=spectre insensitive=yes
//  v2011.1_15.11    thu feb 10 17:20:50 pst 2011
global 0 gnd vcc
aliasGnd ( gnd 0 ) vsource type=dc dc=0
include "/Cad/DesignK/FaradayUMC180/DigitalCore/BackEnd/lvs/fsa0a_c_generic_core.spi"

subckt sartimerverilog_data8 ( reset clockt statep\[1\] statep\[0\] sarout\[7\]
+ sarout\[6\] sarout\[5\] sarout\[4\] sarout\[3\] sarout\[2\] sarout\[1\] sarout\[0\]
+ sarouti\[7\] sarouti\[6\] sarouti\[5\] sarouti\[4\] sarouti\[3\] sarouti\[2\]
+ sarouti\[1\] sarouti\[0\] )
xsarouti_reg\[0\] ( sarouti\[0\] 1000 n1 clockt n11 ) dffsbn
xsarouti_reg\[1\] ( sarouti\[1\] 1001 n10 clockt n11 ) dffsbn
xsarouti_reg\[2\] ( sarouti\[2\] 1002 n6 clockt n11 ) dffsbn
xsarouti_reg\[7\] ( n20 1003 n5 clockt n11 ) dffsbn
xsarouti_reg\[3\] ( sarouti\[3\] 1004 n4 clockt n11 ) dffsbn
xsarouti_reg\[4\] ( sarouti\[4\] 1005 n3 clockt n11 ) dffsbn
xsarouti_reg\[5\] ( sarouti\[5\] 1006 n2 clockt n11 ) dffsbp
xsarouti_reg\[6\] ( sarouti\[6\] 1007 n8 clockt n11 ) dffsbt
xg252 ( n10 n9 sarout\[1\] sarouti\[1\] n9 ) moai1s
xg253 ( n8 n9 sarout\[6\] sarouti\[6\] n9 ) moai1s
xg247 ( n6 n9 sarout\[2\] sarouti\[2\] n9 ) moai1s
xg254 ( n5 n9 sarout\[7\] n20 n9 ) moai1s
xg248 ( n4 n9 sarout\[3\] sarouti\[3\] n9 ) moai1s
xg249 ( n3 n9 sarout\[4\] sarouti\[4\] n9 ) moai1s
xg250 ( n2 n9 sarout\[5\] sarouti\[5\] n9 ) moai1s
xg251 ( n1 n9 sarout\[0\] sarouti\[0\] n9 ) moai1s
xg255 ( n9 statep\[1\] statep\[0\] ) xor2
xg258 ( sarouti\[7\] n20 ) buf6ck
xg256 ( n11 reset ) inv1s
ends sartimerverilog_data8
