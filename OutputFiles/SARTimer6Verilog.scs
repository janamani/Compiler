// $ Spice netlist generated by v2lvs
simulator lang=spectre insensitive=yes
//  v2011.1_15.11    thu feb 10 17:20:50 pst 2011
//  global 0 gnd vcc
//  aliasGnd ( gnd 0 ) vsource type=dc dc=0
include "/Cad/DesignK/FaradayUMC180/DigitalCore/BackEnd/lvs/fsa0a_c_generic_core.scs"

subckt sartimer6verilog ( statep\[1\] statep\[0\] sarout\[7\] sarout\[6\] sarout\[5\]
+ sarout\[4\] sarout\[3\] sarout\[2\] sarout\[1\] sarout\[0\] clockt reset inc dcr
+ ready resetp resetn saroutis saroutds saroutig saroutdg saroutcg clockdcr clockinc
+ clocktck dataout\[7\] dataout\[6\] dataout\[5\] dataout\[4\] dataout\[3\] dataout\[2\]
+ dataout\[1\] dataout\[0\] timerout\[5\] timerout\[4\] timerout\[3\] timerout\[2\]
+ timerout\[1\] timerout\[0\] sarouti\[7\] sarouti\[6\] sarouti\[5\] sarouti\[4\]
+ sarouti\[3\] sarouti\[2\] sarouti\[1\] sarouti\[0\] saroutd\[7\] saroutd\[6\]
+ saroutd\[5\] saroutd\[4\] saroutd\[3\] saroutd\[2\] saroutd\[1\] saroutd\[0\]
+ saroutc\[7\] saroutc\[6\] saroutc\[5\] saroutc\[4\] saroutc\[3\] saroutc\[2\]
+ saroutc\[1\] saroutc\[0\] )
xg200 ( clocktck clockdcr ) buf4
xg201 ( clockinc clockdcr ) buf4
xg202 ( saroutcg resetn ) buf4
xg203 ( saroutdg resetn ) buf4
xg204 ( saroutig resetn ) buf4
xg205 ( saroutds saroutis ) buf4
xg206 ( saroutis resetp ) buf4
xg441 ( sarouti\[7\] n170 ) buf6ck
xg442 ( saroutd\[7\] n178 ) buf6ck
xg450 ( resetp reset ) buf2
xg512 ( n118 n373 ) inv1s
xready_reg ( ready n327 clockt resetn ) qdffrbs
xg518 ( clockdcr clockt resetp n83 ) nr3t
xsaroutc_reg\[0\] ( saroutc\[0\] 1000 n403 clockt resetn ) dffsbn
xsaroutc_reg\[1\] ( saroutc\[1\] 1001 n213 clockt resetn ) dffsbn
xsaroutc_reg\[7\] ( n330 1002 n117 clockt resetn ) dffsbn
xsaroutc_reg\[6\] ( saroutc\[6\] 1003 n122 clockt resetn ) dffsbn
xsaroutc_reg\[5\] ( saroutc\[5\] 1004 n369 clockt resetn ) dffsbn
xsaroutc_reg\[4\] ( saroutc\[4\] 1005 n125 clockt resetn ) dffsbn
xsaroutc_reg\[3\] ( saroutc\[3\] 1006 n12 clockt resetn ) dffsbn
xsaroutc_reg\[2\] ( saroutc\[2\] 1007 n453 clockt resetn ) dffsbn
xg523 ( n83 n118 n472 ) nr2
xg526 ( resetn resetp ) inv2
xg527 ( n125 sarout\[4\] ) inv1s
xg529 ( n129 sarout\[0\] ) inv3
xg530 ( n122 sarout\[6\] ) inv1s
xg532 ( n117 sarout\[7\] ) inv1s
xsaroutd_reg\[7\] ( n178 1008 n510 clockt resetn ) dffsbn
xsaroutd_reg\[6\] ( saroutd\[6\] 1009 n322 clockt resetn ) dffsbt
xsaroutd_reg\[5\] ( saroutd\[5\] 1010 n293 clockt resetn ) dffsbp
xg1432 ( n79 n474 n465 ) nd2p
xsaroutd_reg\[4\] ( saroutd\[4\] 1011 n75 clockt resetn ) dffsbn
xg1438 ( n75 n483 n391 ) nd2s
xsaroutd_reg\[3\] ( saroutd\[3\] 1012 n71 clockt resetn ) dffsbn
xg1444 ( n71 n69 n391 ) nd2
xg1446 ( n69 n454 n62 n457 saroutd\[3\] ) aoi22s
xsaroutd_reg\[2\] ( saroutd\[2\] 1013 n383 clockt resetn ) dffsbn
xtemptmr_reg\[3\] ( temptmr\[3\] n431 clockt resetn ) qdffrbp
xsarouti_reg\[1\] ( sarouti\[1\] 1014 n61 clockt resetn ) dffsbn
xsarouti_reg\[2\] ( sarouti\[2\] 1015 n60 clockt resetn ) dffsbn
xsarouti_reg\[3\] ( sarouti\[3\] 1016 n59 clockt resetn ) dffsbn
xsarouti_reg\[4\] ( sarouti\[4\] 1017 n58 clockt resetn ) dffsbn
xsarouti_reg\[5\] ( sarouti\[5\] 1018 n57 clockt resetn ) dffsbp
xsarouti_reg\[6\] ( sarouti\[6\] 1019 n56 clockt resetn ) dffsbt
xsarouti_reg\[7\] ( n170 1020 n55 clockt resetn ) dffsbn
xsarouti_reg\[0\] ( sarouti\[0\] 1021 n64 clockt resetn ) dffsbn
xtemptmr_reg\[2\] ( temptmr\[2\] n53 clockt resetn ) qdffrbp
xg1462 ( n64 n52 n50 ) nd2
xg1464 ( n62 n405 sarout\[3\] n405 sarout\[3\] ) moai1
xg1465 ( n61 n48 n214 n459 sarouti\[1\] ) moai1
xg1466 ( n60 n48 n449 n459 sarouti\[2\] ) moai1
xg1467 ( n59 n48 sarout\[3\] n459 sarouti\[3\] ) moai1
xg1468 ( n58 n48 sarout\[4\] n459 sarouti\[4\] ) moai1
xg1469 ( n57 n48 sarout\[5\] n459 sarouti\[5\] ) moai1
xg1470 ( n56 n48 sarout\[6\] n459 sarouti\[6\] ) moai1
xg1471 ( n55 n48 sarout\[7\] n459 n170 ) moai1
xsaroutd_reg\[1\] ( saroutd\[1\] 1022 n46 clockt resetn ) dffsbn
xtemptmr_reg\[5\] ( temptmr\[5\] n49 clockt resetn ) qdffrbn
xg1475 ( n53 n43 n327 ) nr2
xg1476 ( n52 n486 n403 ) nd2s
xg1477 ( n51 n405 n12 ) nd2t
xg1478 ( n50 n454 n485 n457 sarouti\[0\] ) aoi22s
xsaroutd_reg\[0\] ( saroutd\[0\] 1023 n45 clockt resetn ) dffsbn
xg1480 ( n49 n501 n327 ) nr2
xg1481 ( n48 n486 ) inv3
xg1483 ( n46 n40 n391 ) nd2
xtemptmr_reg\[4\] ( temptmr\[4\] n39 clockt resetn ) qdffrbp
xtemptmr_reg\[1\] ( n219 n37 clockt resetn ) qdffrbp
xg1486 ( n45 n27 n391 ) nd2
xg1488 ( n43 temptmr\[2\] n14 ) xor2hs
xg1491 ( n40 n454 n301 n457 saroutd\[1\] ) aoi22s
xg1492 ( n39 n440 n327 ) nr2
xg1495 ( n37 n0 n327 ) nr2
xdataout_reg\[0\] ( dataout\[0\] 1024 dataout\[0\] sarout\[0\] clockt n400 resetn
+ ) dfzsbn
xtimerout_reg\[3\] ( timerout\[3\] n21 clockt resetn ) qdffrbn
xtimerout_reg\[4\] ( timerout\[4\] n26 clockt resetn ) qdffrbn
xtimerout_reg\[5\] ( timerout\[5\] n25 clockt resetn ) qdffrbn
xtimerout_reg\[0\] ( timerout\[0\] n24 clockt resetn ) qdffrbn
xtimerout_reg\[1\] ( timerout\[1\] n23 clockt resetn ) qdffrbn
xtimerout_reg\[2\] ( timerout\[2\] n22 clockt resetn ) qdffrbn
xdataout_reg\[1\] ( dataout\[1\] n214 dataout\[1\] clockt n401 resetn ) qdfzrbn
xdataout_reg\[2\] ( dataout\[2\] n449 dataout\[2\] clockt n401 resetn ) qdfzrbn
xdataout_reg\[3\] ( dataout\[3\] sarout\[3\] dataout\[3\] clockt n401 resetn ) qdfzrbn
xdataout_reg\[4\] ( dataout\[4\] sarout\[4\] dataout\[4\] clockt n401 resetn ) qdfzrbn
xdataout_reg\[5\] ( dataout\[5\] sarout\[5\] dataout\[5\] clockt n401 resetn ) qdfzrbn
xdataout_reg\[6\] ( dataout\[6\] sarout\[6\] dataout\[6\] clockt n401 resetn ) qdfzrbn
xdataout_reg\[7\] ( dataout\[7\] sarout\[7\] dataout\[7\] clockt n401 resetn ) qdfzrbn
xg1520 ( n27 n459 saroutd\[0\] n465 sarout\[0\] ) aoi22s
xg1521 ( n26 n480 timerout\[4\] temptmr\[4\] ) mux2
xg1522 ( n25 n480 timerout\[5\] temptmr\[5\] ) mux2
xg1523 ( n24 n480 timerout\[0\] temptmr\[0\] ) mux2
xg1524 ( n23 n480 timerout\[1\] n393 ) mux2
xg1525 ( n22 n480 timerout\[2\] temptmr\[2\] ) mux2
xg1526 ( n21 n480 timerout\[3\] temptmr\[3\] ) mux2
xg1530 ( n19 n459 n178 ) nd2s
xg1533 ( n16 n449 sarout\[3\] ) nr2
xg1534 ( n15 sarout\[4\] sarout\[5\] ) nr2
xg1535 ( n14 temptmr\[0\] n393 ) nd2
xg1539 ( n12 sarout\[3\] ) inv2
xg1558 ( n3 n480 temptmr\[0\] ) or2b1s
xg1561 ( n0 n393 temptmr\[0\] ) xnr2hs
xfopt1578 ( n213 n214 ) inv1s
xfopt1580 ( n214 sarout\[1\] ) buf2
xg157 ( n275 statep\[0\] ) inv2
xg91 ( n293 n391 n444 ) nd2
xg37 ( n301 sarout\[0\] n300 sarout\[1\] ) mxl2s
xg39 ( n300 sarout\[1\] ) inv2
xg33 ( n322 n79 n424 ) nd2
xg3 ( n326 n480 ) inv3ck
xg1639 ( n327 n326 ) inv4
xfopt ( saroutc\[7\] n330 ) buf6ck
xg158 ( n363 n51 ) inv2
xg156 ( n364 sarout\[5\] sarout\[4\] ) nr2
xg1661 ( n368 sarout\[4\] n51 ) nr2p
xg159 ( n369 sarout\[5\] ) inv1s
xg99 ( n383 n391 n382 ) nd2s
xg110 ( n372 n386 n275 ) nd2p
xg113 ( n373 statep\[1\] statep\[0\] ) nd2p
xg100 ( n382 n459 n407 n454 saroutd\[2\] ) oai22s
xg28 ( n384 inc dcr ) nr2p
xg29 ( n386 statep\[1\] ) inv3
xg30 ( n391 n390 ) inv2
xg31 ( n390 n389 n16 n15 n457 ) an4b1
xg32 ( n389 sarout\[6\] n214 sarout\[7\] ) nr3h
xg1667 ( n393 n219 ) buf1ck
xg1672 ( n397 temptmr\[5\] temptmr\[4\] ) an2s
xg1673 ( n400 n399 ) inv3
xg1674 ( n399 n275 n386 ) nd2p
xg1675 ( n401 n400 ) inv4ck
xg1677 ( n403 n129 ) buf1ck
xg1678 ( n405 n449 n404 ) nr2f
xg1679 ( n404 n300 n129 ) nd2f
xg1680 ( n407 n449 n404 ) xor2hs
xg43 ( n414 n372 n373 ) nd2f
xg49 ( n417 n497 n414 ) nd2p
xg45 ( n422 n498 n480 ) or2s
xg16 ( n424 n390 n459 saroutd\[6\] ) aoi12s
xg21 ( n427 reset n495 ) nr2
xg1687 ( n431 n430 n327 ) nr2
xg24 ( n430 temptmr\[3\] n1 ) xnr2hs
xg1688 ( n444 n459 n513 n454 saroutd\[5\] ) oai22s
xg34 ( n513 sarout\[5\] n368 ) xnr2hs
xg57 ( n438 n436 temptmr\[4\] ) nd2
xg58 ( n436 n435 n496 ) nr2t
xg59 ( n435 temptmr\[2\] temptmr\[3\] n219 ) nd3p
xg54 ( n440 n438 n436 temptmr\[4\] ) oai12s
xg55 ( n446 n397 n436 ) nd2p
xfopt1697 ( n449 n453 ) inv3
xfopt1699 ( n453 sarout\[2\] ) inv2
xfopt1701 ( n454 n457 ) inv2
xfopt1703 ( n457 n414 ) inv6
xfopt1704 ( n465 n459 ) inv2
xfopt1706 ( n459 n457 ) buf8
xg1708 ( n472 n399 n471 ) nr2
xg1709 ( n471 reset gnd n384 ) nr3h
xg1710 ( n474 sarout\[6\] n473 ) xor2hs
xg1711 ( n473 n363 n364 ) nd2p
xg1712 ( n476 n475 n473 ) nr2t
xfopt1713 ( n475 sarout\[6\] ) buf1ck
xg11 ( n480 n479 n446 ) nd2f
xg12 ( n479 n427 n417 ) nd2t
xg36 ( n483 n482 n454 n457 saroutd\[4\] ) aoi22s
xg1715 ( n482 sarout\[4\] n51 ) xor2hs
xg25 ( n485 n502 n514 ) nr2
xtemptmr_reg\[0\] ( temptmr\[0\] n496 n3 clockt resetn ) dffrbn
xg2 ( n497 n384 n386 ) or2b1s
xg1725 ( n498 n417 reset ) an2b1s
xg1727 ( n501 temptmr\[5\] n438 ) xor2hs
xg1728 ( n502 sarout\[7\] sarout\[4\] sarout\[5\] sarout\[6\] ) nd4
xflagtmr_reg ( n495 n422 clockt resetn ) qdffrbn
xg1731 ( n1 temptmr\[2\] n14 ) an2b1
xg1735 ( n486 n414 ) dela
xg1736 ( n510 n19 n511 n459 ) oai12s
xg1739 ( 1025 n511 sarout\[7\] n476 ) ha2
xg1740 ( n514 sarout\[3\] sarout\[2\] n214 ) nd3
ends sartimer6verilog
