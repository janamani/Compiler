// $ Spice netlist generated by v2lvs
simulator lang=spectre insensitive=yes
//  v2011.1_15.11    thu feb 10 17:20:50 pst 2011
//  global 0 gnd vcc
//  aliasGnd ( gnd 0 ) vsource type=dc dc=0
include "/Cad/DesignK/FaradayUMC180/DigitalCore/BackEnd/lvs/fsa0a_c_generic_core.scs"

subckt sartestcontrols ( statep\[1\] statep\[0\] clockt reset inc dcr resetp resetn saroutis saroutds
+ saroutig saroutdg saroutcg clockdcr clockinc clocktck )

xg201 ( saroutcg reset ) inv2
xg202 ( saroutdg reset ) inv2
xg203 ( saroutig reset ) inv2
xg204 ( saroutds reset ) buf2
xg205 ( saroutis reset ) buf2
xg206 ( resetp reset ) buf2
xg207 ( resetn reset ) inv2

xg300 ( clocktck clockdcr ) buf2
xg301 ( clockinc clockdcr ) buf2
xg303 ( clockdcr clockt resetp n301 ) nr3t
xg304 ( n301 n302 n304 ) nr2
xg305 ( n302 n303 ) inv1s
xg306 ( n303 statep\[1\] statep\[0\] ) nd2p
xg307 ( n304 n305 n308 n309 ) aoi12s
xg308 ( n305 n306 n307 ) nd2t
xg309 ( n306 statep\[1\] ) inv3
xg310 ( n307 statep\[0\] ) inv3
xg311 ( n308 dcr inc ) or2
xg302 ( n309 reset ) inv1s

ends sartestcontrols
